* NGSPICE file created from ldo_flat.ext - technology: gf180mcuD

.subckt ldo_flat VIN VOUT VSS VREF EN FB_BUF EAOUT_BUF
X0 VIN.t80 EAOUT.t161 VOUT.t47 VIN.t22 pfet_06v0 ad=0.84p pd=3.56u as=0.84p ps=3.56u w=3u l=0.55u
X1 VSS.t79 VSS.t76 VSS.t78 VSS.t77 nfet_06v0 ad=5.8p pd=21.16u as=0 ps=0 w=10u l=3u
X2 VIN.t12 EAOUT.t19 VOUT.t5 VIN.t11 pfet_06v0 ad=0.84p pd=3.56u as=0.84p ps=3.56u w=3u l=0.55u
X3 VOUT.t201 EAOUT.t26 VIN.t260 VIN.t53 pfet_06v0 ad=0.84p pd=3.56u as=0.84p ps=3.56u w=3u l=0.55u
X4 VIN.t52 EAOUT.t145 VOUT.t24 VIN.t51 pfet_06v0 ad=0.84p pd=3.56u as=0.84p ps=3.56u w=3u l=0.55u
X5 VOUT.t208 EAOUT.t138 VIN.t272 VIN.t36 pfet_06v0 ad=0.84p pd=3.56u as=0.84p ps=3.56u w=3u l=0.55u
X6 VOUT.t122 EAOUT.t96 VIN.t179 VIN.t2 pfet_06v0 ad=0.84p pd=3.56u as=1.8p ps=7.2u w=3u l=0.55u
X7 VOUT.t107 EAOUT.t80 VIN.t160 VIN.t57 pfet_06v0 ad=0.84p pd=3.56u as=0.84p ps=3.56u w=3u l=0.55u
X8 VIN.t155 EAOUT.t73 VOUT.t102 VIN.t13 pfet_06v0 ad=0.84p pd=3.56u as=0.84p ps=3.56u w=3u l=0.55u
X9 VOUT.t36 EAOUT.t124 VIN.t69 VIN.t68 pfet_06v0 ad=0.84p pd=3.56u as=0.84p ps=3.56u w=3u l=0.55u
X10 VIN.t238 EAOUT.t59 VOUT.t181 VIN.t132 pfet_06v0 ad=0.84p pd=3.56u as=0.84p ps=3.56u w=3u l=0.55u
X11 VOUT.t190 EAOUT.t8 VIN.t247 VIN.t48 pfet_06v0 ad=0.84p pd=3.56u as=0.84p ps=3.56u w=3u l=0.55u
X12 VIN.t21 EAOUT.t15 VOUT.t9 VIN.t20 pfet_06v0 ad=0.84p pd=3.56u as=0.84p ps=3.56u w=3u l=0.55u
X13 VIN.t19 EAOUT.t31 VOUT.t8 VIN.t18 pfet_06v0 ad=0.84p pd=3.56u as=0.84p ps=3.56u w=3u l=0.55u
X14 VIN.t135 EAOUT.t209 VOUT.t84 VIN.t132 pfet_06v0 ad=0.84p pd=3.56u as=0.84p ps=3.56u w=3u l=0.55u
X15 a_14092_25063# a_15052_15075# VSS.t26 ppolyf_u_1k_6p0 r_width=2u r_length=49.33u
X16 VOUT.t132 EAOUT.t102 VIN.t189 VIN.t39 pfet_06v0 ad=0.84p pd=3.56u as=0.84p ps=3.56u w=3u l=0.55u
X17 VIN.t220 EAOUT.t37 VOUT.t163 VIN.t16 pfet_06v0 ad=1.8p pd=7.2u as=0.84p ps=3.56u w=3u l=0.55u
X18 VIN.t78 EAOUT.t187 VOUT.t45 VIN.t16 pfet_06v0 ad=1.8p pd=7.2u as=0.84p ps=3.56u w=3u l=0.55u
X19 FB_BUF.t1 a_644_14636.t7 VSS.t11 VSS.t10 nfet_05v0 ad=1.5p pd=6.2u as=1.5p ps=6.2u w=2.5u l=0.6u
X20 VIN.t244 EAOUT.t169 VOUT.t187 VIN.t11 pfet_06v0 ad=0.84p pd=3.56u as=0.84p ps=3.56u w=3u l=0.55u
X21 FB_BUF.t0 a_644_14636.t8 VSS.t4 VSS.t3 nfet_05v0 ad=1.5p pd=6.2u as=1.5p ps=6.2u w=2.5u l=0.6u
X22 a_14572_25063# a_15532_15075# VSS.t42 ppolyf_u_1k_6p0 r_width=2u r_length=49.33u
X23 VOUT.t79 EAOUT.t176 VIN.t129 VIN.t53 pfet_06v0 ad=0.84p pd=3.56u as=0.84p ps=3.56u w=3u l=0.55u
X24 VIN.t240 EAOUT.t181 VOUT.t183 VIN.t18 pfet_06v0 ad=0.84p pd=3.56u as=0.84p ps=3.56u w=3u l=0.55u
X25 VIN.t122 EAOUT.t165 VOUT.t72 VIN.t20 pfet_06v0 ad=0.84p pd=3.56u as=0.84p ps=3.56u w=3u l=0.55u
X26 VOUT.t56 EAOUT.t158 VIN.t89 VIN.t48 pfet_06v0 ad=0.84p pd=3.56u as=0.84p ps=3.56u w=3u l=0.55u
X27 VIN.t186 EAOUT.t95 VOUT.t129 VIN.t28 pfet_06v0 ad=0.84p pd=3.56u as=0.84p ps=3.56u w=3u l=0.55u
X28 VOUT.t142 EAOUT.t88 VIN.t199 VIN.t26 pfet_06v0 ad=0.84p pd=3.56u as=0.84p ps=3.56u w=3u l=0.55u
X29 a_14092_25063# VSS.t21 VSS.t20 ppolyf_u_1k_6p0 r_width=2u r_length=49.33u
X30 a_18233_3337.t3 a_18233_3337.t2 VSS.t19 VSS.t18 nfet_05v0 ad=1.5p pd=6.2u as=1.5p ps=6.2u w=2.5u l=0.6u
X31 VIN.t42 EAOUT.t23 VOUT.t18 VIN.t41 pfet_06v0 ad=0.84p pd=3.56u as=0.84p ps=3.56u w=3u l=0.55u
X32 VOUT.t13 EAOUT.t30 VIN.t31 VIN.t30 pfet_06v0 ad=0.84p pd=3.56u as=0.84p ps=3.56u w=3u l=0.55u
X33 VIN.t257 EAOUT.t149 VOUT.t198 VIN.t132 pfet_06v0 ad=0.84p pd=3.56u as=0.84p ps=3.56u w=3u l=0.55u
X34 a_28055_3556.t0 a_18233_3337.t6 VSS.t1 VSS.t0 nfet_05v0 ad=1.5p pd=6.2u as=1.5p ps=6.2u w=2.5u l=0.6u
X35 VIN.t120 VIN.t117 VIN.t119 VIN.t118 pfet_06v0 ad=2.9p pd=11.16u as=0 ps=0 w=5u l=3u
X36 a_11564_14636.t3 a_644_14636.t5 VSS.t55 ppolyf_u_1k_6p0 r_width=1u r_length=1.94754m
X37 VOUT.t134 EAOUT.t84 VIN.t191 VIN.t4 pfet_06v0 ad=0.84p pd=3.56u as=0.84p ps=3.56u w=3u l=0.55u
X38 VIN.t145 EAOUT.t63 VOUT.t92 VIN.t144 pfet_06v0 ad=0.84p pd=3.56u as=0.84p ps=3.56u w=3u l=0.55u
X39 EAOUT.t2 a_25212_9686.t7 a_25710_9686.t2 VIN.t45 pfet_06v0 ad=1.5p pd=6.2u as=1.5p ps=6.2u w=2.5u l=0.55u
X40 a_14572_25063# a_13612_15075# VSS.t16 ppolyf_u_1k_6p0 r_width=2u r_length=49.33u
X41 VIN.t224 EAOUT.t213 VOUT.t167 VIN.t144 pfet_06v0 ad=0.84p pd=3.56u as=0.84p ps=3.56u w=3u l=0.55u
X42 VIN.t72 EAOUT.t127 VOUT.t39 VIN.t16 pfet_06v0 ad=1.8p pd=7.2u as=0.84p ps=3.56u w=3u l=0.55u
X43 VOUT.t148 EAOUT.t122 VIN.t205 VIN.t142 pfet_06v0 ad=0.84p pd=3.56u as=0.84p ps=3.56u w=3u l=0.55u
X44 VOUT.t157 EAOUT.t106 VIN.t214 VIN.t34 pfet_06v0 ad=0.84p pd=3.56u as=0.84p ps=3.56u w=3u l=0.55u
X45 VIN.t182 EAOUT.t99 VOUT.t125 VIN.t8 pfet_06v0 ad=0.84p pd=3.56u as=0.84p ps=3.56u w=3u l=0.55u
X46 VIN.t236 EAOUT.t57 VOUT.t179 VIN.t43 pfet_06v0 ad=0.84p pd=3.56u as=0.84p ps=3.56u w=3u l=0.55u
X47 VSS.t63 VSS.t60 VSS.t62 VSS.t61 nfet_05v0 ad=1.45p pd=6.16u as=0 ps=0 w=2.5u l=0.6u
X48 VIN.t159 EAOUT.t41 VOUT.t106 VIN.t22 pfet_06v0 ad=0.84p pd=3.56u as=0.84p ps=3.56u w=3u l=0.55u
X49 VIN.t255 EAOUT.t207 VOUT.t196 VIN.t43 pfet_06v0 ad=0.84p pd=3.56u as=0.84p ps=3.56u w=3u l=0.55u
X50 VIN.t86 EAOUT.t191 VOUT.t53 VIN.t22 pfet_06v0 ad=0.84p pd=3.56u as=0.84p ps=3.56u w=3u l=0.55u
X51 a_25212_9686.t1 FB a_28055_3556.t4 VSS.t40 nfet_06v0 ad=6p pd=21.2u as=6p ps=21.2u w=10u l=3u
X52 VOUT.t182 EAOUT.t180 VIN.t239 VIN.t30 pfet_06v0 ad=0.84p pd=3.56u as=0.84p ps=3.56u w=3u l=0.55u
X53 VIN.t96 EAOUT.t173 VOUT.t63 VIN.t41 pfet_06v0 ad=0.84p pd=3.56u as=0.84p ps=3.56u w=3u l=0.55u
X54 VOUT.t205 EAOUT.t34 VIN.t267 VIN.t68 pfet_06v0 ad=0.84p pd=3.56u as=0.84p ps=3.56u w=3u l=0.55u
X55 VIN.t228 EAOUT.t153 VOUT.t171 VIN.t144 pfet_06v0 ad=0.84p pd=3.56u as=0.84p ps=3.56u w=3u l=0.55u
X56 VIN.t217 EAOUT.t77 VOUT.t160 VIN.t6 pfet_06v0 ad=0.84p pd=3.56u as=0.84p ps=3.56u w=3u l=0.55u
X57 VOUT.t95 EAOUT.t70 VIN.t148 VIN.t65 pfet_06v0 ad=0.84p pd=3.56u as=0.84p ps=3.56u w=3u l=0.55u
X58 VIN.t251 EAOUT.t49 VOUT.t192 VIN.t11 pfet_06v0 ad=0.84p pd=3.56u as=0.84p ps=3.56u w=3u l=0.55u
X59 VOUT.t41 EAOUT.t12 VIN.t74 VIN.t39 pfet_06v0 ad=0.84p pd=3.56u as=0.84p ps=3.56u w=3u l=0.55u
X60 VOUT.t178 EAOUT.t56 VIN.t235 VIN.t53 pfet_06v0 ad=0.84p pd=3.56u as=0.84p ps=3.56u w=3u l=0.55u
X61 VOUT.t195 EAOUT.t206 VIN.t254 VIN.t53 pfet_06v0 ad=0.84p pd=3.56u as=0.84p ps=3.56u w=3u l=0.55u
X62 VIN.t94 EAOUT.t199 VOUT.t61 VIN.t11 pfet_06v0 ad=0.84p pd=3.56u as=0.84p ps=3.56u w=3u l=0.55u
X63 VIN.t55 EAOUT.t147 VOUT.t26 VIN.t43 pfet_06v0 ad=0.84p pd=3.56u as=0.84p ps=3.56u w=3u l=0.55u
X64 VIN.t102 EAOUT.t131 VOUT.t69 VIN.t22 pfet_06v0 ad=0.84p pd=3.56u as=0.84p ps=3.56u w=3u l=0.55u
X65 VOUT.t38 EAOUT.t126 VIN.t71 VIN.t2 pfet_06v0 ad=0.84p pd=3.56u as=1.8p ps=7.2u w=3u l=0.55u
X66 VOUT.t109 EAOUT.t82 VIN.t162 VIN.t62 pfet_06v0 ad=0.84p pd=3.56u as=0.84p ps=3.56u w=3u l=0.55u
X67 VOUT.t120 EAOUT.t110 VIN.t177 VIN.t57 pfet_06v0 ad=0.84p pd=3.56u as=0.84p ps=3.56u w=3u l=0.55u
X68 VIN.t190 EAOUT.t103 VOUT.t133 VIN.t13 pfet_06v0 ad=0.84p pd=3.56u as=0.84p ps=3.56u w=3u l=0.55u
X69 VIN.t141 EAOUT.t61 VOUT.t90 VIN.t18 pfet_06v0 ad=0.84p pd=3.56u as=0.84p ps=3.56u w=3u l=0.55u
X70 VOUT.t22 EAOUT.t38 VIN.t49 VIN.t48 pfet_06v0 ad=0.84p pd=3.56u as=0.84p ps=3.56u w=3u l=0.55u
X71 VIN.t211 EAOUT.t45 VOUT.t154 VIN.t20 pfet_06v0 ad=0.84p pd=3.56u as=0.84p ps=3.56u w=3u l=0.55u
X72 VIN.t137 EAOUT.t211 VOUT.t86 VIN.t18 pfet_06v0 ad=0.84p pd=3.56u as=0.84p ps=3.56u w=3u l=0.55u
X73 VOUT.t50 EAOUT.t188 VIN.t83 VIN.t48 pfet_06v0 ad=0.84p pd=3.56u as=0.84p ps=3.56u w=3u l=0.55u
X74 VIN.t234 EAOUT.t195 VOUT.t177 VIN.t20 pfet_06v0 ad=0.84p pd=3.56u as=0.84p ps=3.56u w=3u l=0.55u
X75 VOUT.t42 EAOUT.t184 VIN.t75 VIN.t68 pfet_06v0 ad=0.84p pd=3.56u as=0.84p ps=3.56u w=3u l=0.55u
X76 a_1786_3337# EN.t0 VSS.t28 VSS.t27 nfet_06v0 ad=0.3p pd=2.2u as=0.3p ps=2.2u w=0.5u l=5u
X77 VOUT.t48 EAOUT.t162 VIN.t81 VIN.t39 pfet_06v0 ad=0.84p pd=3.56u as=0.84p ps=3.56u w=3u l=0.55u
X78 VOUT.t25 EAOUT.t146 VIN.t54 VIN.t53 pfet_06v0 ad=0.84p pd=3.56u as=0.84p ps=3.56u w=3u l=0.55u
X79 VIN.t273 EAOUT.t139 VOUT.t209 VIN.t11 pfet_06v0 ad=0.84p pd=3.56u as=0.84p ps=3.56u w=3u l=0.55u
X80 VIN.t161 EAOUT.t81 VOUT.t108 VIN.t46 pfet_06v0 ad=0.84p pd=3.56u as=0.84p ps=3.56u w=3u l=0.55u
X81 VOUT.t103 EAOUT.t74 VIN.t156 VIN.t0 pfet_06v0 ad=0.84p pd=3.56u as=0.84p ps=3.56u w=3u l=0.55u
X82 VSS.t67 VSS.t64 VSS.t66 VSS.t65 nfet_05v0 ad=1.45p pd=6.16u as=0 ps=0 w=2.5u l=0.6u
X83 a_3623_3336.t0 a_1786_3337# VIN.t262 VIN.t261 pfet_06v0 ad=3p pd=11.2u as=3p ps=11.2u w=5u l=0.6u
X84 VIN.t70 EAOUT.t125 VOUT.t37 VIN.t28 pfet_06v0 ad=0.84p pd=3.56u as=0.84p ps=3.56u w=3u l=0.55u
X85 VOUT.t140 EAOUT.t118 VIN.t197 VIN.t26 pfet_06v0 ad=0.84p pd=3.56u as=0.84p ps=3.56u w=3u l=0.55u
X86 VOUT.t89 EAOUT.t60 VIN.t140 VIN.t30 pfet_06v0 ad=0.84p pd=3.56u as=0.84p ps=3.56u w=3u l=0.55u
X87 VIN.t9 EAOUT.t9 VOUT.t4 VIN.t8 pfet_06v0 ad=0.84p pd=3.56u as=0.84p ps=3.56u w=3u l=0.55u
X88 VOUT.t191 EAOUT.t32 VIN.t248 VIN.t142 pfet_06v0 ad=0.84p pd=3.56u as=0.84p ps=3.56u w=3u l=0.55u
X89 VIN.t277 EAOUT.t53 VOUT.t211 VIN.t41 pfet_06v0 ad=0.84p pd=3.56u as=0.84p ps=3.56u w=3u l=0.55u
X90 VOUT.t85 EAOUT.t210 VIN.t136 VIN.t30 pfet_06v0 ad=0.84p pd=3.56u as=0.84p ps=3.56u w=3u l=0.55u
X91 VIN.t128 EAOUT.t203 VOUT.t78 VIN.t41 pfet_06v0 ad=0.84p pd=3.56u as=0.84p ps=3.56u w=3u l=0.55u
X92 VIN.t259 EAOUT.t151 VOUT.t200 VIN.t18 pfet_06v0 ad=0.84p pd=3.56u as=0.84p ps=3.56u w=3u l=0.55u
X93 VOUT.t66 EAOUT.t128 VIN.t99 VIN.t48 pfet_06v0 ad=0.84p pd=3.56u as=0.84p ps=3.56u w=3u l=0.55u
X94 VOUT.t14 EAOUT.t16 VIN.t35 VIN.t34 pfet_06v0 ad=0.84p pd=3.56u as=0.84p ps=3.56u w=3u l=0.55u
X95 VIN.t169 EAOUT.t135 VOUT.t116 VIN.t20 pfet_06v0 ad=0.84p pd=3.56u as=0.84p ps=3.56u w=3u l=0.55u
X96 VOUT.t152 EAOUT.t114 VIN.t209 VIN.t4 pfet_06v0 ad=0.84p pd=3.56u as=0.84p ps=3.56u w=3u l=0.55u
X97 a_18233_3337.t5 a_1786_3337# VSS.t48 VSS.t47 nfet_05v0 ad=0.6p pd=3.2u as=0.6p ps=3.2u w=1u l=0.6u
X98 VIN.t10 EAOUT.t6 EAOUT_BUF.t0 VSS.t2 nfet_05v0 ad=3p pd=11.2u as=3p ps=11.2u w=5u l=0.6u
X99 VOUT.t184 EAOUT.t182 VIN.t241 VIN.t142 pfet_06v0 ad=0.84p pd=3.56u as=0.84p ps=3.56u w=3u l=0.55u
X100 VOUT.t73 EAOUT.t166 VIN.t123 VIN.t34 pfet_06v0 ad=0.84p pd=3.56u as=0.84p ps=3.56u w=3u l=0.55u
X101 VIN.t90 EAOUT.t159 VOUT.t57 VIN.t8 pfet_06v0 ad=0.84p pd=3.56u as=0.84p ps=3.56u w=3u l=0.55u
X102 VIN.t64 EAOUT.t143 VOUT.t33 VIN.t41 pfet_06v0 ad=0.84p pd=3.56u as=0.84p ps=3.56u w=3u l=0.55u
X103 EAOUT.t5 VOUT.t203 cap_mim_2f0_m4m5_noshield c_width=38.6u c_length=38.6u
X104 VOUT.t199 EAOUT.t150 VIN.t258 VIN.t30 pfet_06v0 ad=0.84p pd=3.56u as=0.84p ps=3.56u w=3u l=0.55u
X105 VIN.t192 EAOUT.t85 VOUT.t135 VIN.t51 pfet_06v0 ad=0.84p pd=3.56u as=0.84p ps=3.56u w=3u l=0.55u
X106 VOUT.t161 EAOUT.t78 VIN.t218 VIN.t36 pfet_06v0 ad=0.84p pd=3.56u as=0.84p ps=3.56u w=3u l=0.55u
X107 VOUT.t97 EAOUT.t64 VIN.t150 VIN.t68 pfet_06v0 ad=0.84p pd=3.56u as=0.84p ps=3.56u w=3u l=0.55u
X108 VIN.t73 EAOUT.t13 VOUT.t40 VIN.t13 pfet_06v0 ad=0.84p pd=3.56u as=0.84p ps=3.56u w=3u l=0.55u
X109 VOUT.t28 EAOUT.t20 VIN.t58 VIN.t57 pfet_06v0 ad=0.84p pd=3.56u as=0.84p ps=3.56u w=3u l=0.55u
X110 VOUT.t1 EAOUT.t36 VIN.t3 VIN.t2 pfet_06v0 ad=0.84p pd=3.56u as=1.8p ps=7.2u w=3u l=0.55u
X111 VOUT.t168 EAOUT.t214 VIN.t225 VIN.t68 pfet_06v0 ad=0.84p pd=3.56u as=0.84p ps=3.56u w=3u l=0.55u
X112 VIN.t215 EAOUT.t107 VOUT.t158 VIN.t6 pfet_06v0 ad=0.84p pd=3.56u as=0.84p ps=3.56u w=3u l=0.55u
X113 VOUT.t130 EAOUT.t100 VIN.t187 VIN.t65 pfet_06v0 ad=0.84p pd=3.56u as=0.84p ps=3.56u w=3u l=0.55u
X114 EAOUT_BUF.t2 a_644_14636.t6 VSS.t25 VSS.t24 nfet_05v0 ad=1.5p pd=6.2u as=1.5p ps=6.2u w=2.5u l=0.6u
X115 a_644_14636.t3 a_644_14636.t2 VSS.t23 VSS.t22 nfet_05v0 ad=1.5p pd=6.2u as=1.5p ps=6.2u w=2.5u l=0.6u
X116 VOUT.t17 EAOUT.t42 VIN.t40 VIN.t39 pfet_06v0 ad=0.84p pd=3.56u as=0.84p ps=3.56u w=3u l=0.55u
X117 VOUT.t174 EAOUT.t192 VIN.t231 VIN.t39 pfet_06v0 ad=0.84p pd=3.56u as=0.84p ps=3.56u w=3u l=0.55u
X118 VOUT.t150 EAOUT.t112 VIN.t207 VIN.t62 pfet_06v0 ad=0.84p pd=3.56u as=0.84p ps=3.56u w=3u l=0.55u
X119 EAOUT.t1 VREF.t0 a_28055_3556.t3 VSS.t35 nfet_06v0 ad=6p pd=21.2u as=6p ps=21.2u w=10u l=3u
X120 VOUT.t44 EAOUT.t186 VIN.t77 VIN.t2 pfet_06v0 ad=0.84p pd=3.56u as=1.8p ps=7.2u w=3u l=0.55u
X121 VOUT.t188 EAOUT.t170 VIN.t245 VIN.t57 pfet_06v0 ad=0.84p pd=3.56u as=0.84p ps=3.56u w=3u l=0.55u
X122 VIN.t82 EAOUT.t163 VOUT.t49 VIN.t13 pfet_06v0 ad=0.84p pd=3.56u as=0.84p ps=3.56u w=3u l=0.55u
X123 EAOUT.t0 VREF.t1 a_28055_3556.t2 VSS.t34 nfet_06v0 ad=6p pd=21.2u as=6p ps=21.2u w=10u l=3u
X124 VOUT.t11 EAOUT.t28 VIN.t27 VIN.t26 pfet_06v0 ad=0.84p pd=3.56u as=0.84p ps=3.56u w=3u l=0.55u
X125 VIN.t29 EAOUT.t35 VOUT.t12 VIN.t28 pfet_06v0 ad=0.84p pd=3.56u as=0.84p ps=3.56u w=3u l=0.55u
X126 VOUT.t172 EAOUT.t154 VIN.t229 VIN.t68 pfet_06v0 ad=0.84p pd=3.56u as=0.84p ps=3.56u w=3u l=0.55u
X127 VIN.t200 EAOUT.t89 VOUT.t143 VIN.t132 pfet_06v0 ad=0.84p pd=3.56u as=0.84p ps=3.56u w=3u l=0.55u
X128 VOUT.t113 EAOUT.t132 VIN.t166 VIN.t39 pfet_06v0 ad=0.84p pd=3.56u as=0.84p ps=3.56u w=3u l=0.55u
X129 VOUT.t2 EAOUT.t24 VIN.t5 VIN.t4 pfet_06v0 ad=0.84p pd=3.56u as=0.84p ps=3.56u w=3u l=0.55u
X130 a_13132_25063# FB VSS.t41 ppolyf_u_1k_6p0 r_width=2u r_length=49.33u
X131 VIN.t178 EAOUT.t111 VOUT.t121 VIN.t46 pfet_06v0 ad=0.84p pd=3.56u as=0.84p ps=3.56u w=3u l=0.55u
X132 VOUT.t155 EAOUT.t104 VIN.t212 VIN.t0 pfet_06v0 ad=0.84p pd=3.56u as=0.84p ps=3.56u w=3u l=0.55u
X133 VIN.t153 EAOUT.t67 VOUT.t100 VIN.t16 pfet_06v0 ad=1.8p pd=7.2u as=0.84p ps=3.56u w=3u l=0.55u
X134 VOUT.t91 EAOUT.t62 VIN.t143 VIN.t142 pfet_06v0 ad=0.84p pd=3.56u as=0.84p ps=3.56u w=3u l=0.55u
X135 EAOUT.t3 a_25212_9686.t6 a_25710_9686.t1 VIN.t33 pfet_06v0 ad=1.5p pd=6.2u as=1.5p ps=6.2u w=2.5u l=0.55u
X136 VIN.t38 EAOUT.t39 VOUT.t16 VIN.t8 pfet_06v0 ad=0.84p pd=3.56u as=0.84p ps=3.56u w=3u l=0.55u
X137 VOUT.t29 EAOUT.t46 VIN.t59 VIN.t34 pfet_06v0 ad=0.84p pd=3.56u as=0.84p ps=3.56u w=3u l=0.55u
X138 VOUT.t166 EAOUT.t212 VIN.t223 VIN.t142 pfet_06v0 ad=0.84p pd=3.56u as=0.84p ps=3.56u w=3u l=0.55u
X139 VIN.t84 EAOUT.t189 VOUT.t51 VIN.t8 pfet_06v0 ad=0.84p pd=3.56u as=0.84p ps=3.56u w=3u l=0.55u
X140 VOUT.t58 EAOUT.t196 VIN.t91 VIN.t34 pfet_06v0 ad=0.84p pd=3.56u as=0.84p ps=3.56u w=3u l=0.55u
X141 VSS.t59 VSS.t56 VSS.t58 VSS.t57 nfet_05v0 ad=1.45p pd=6.16u as=0 ps=0 w=2.5u l=0.6u
X142 VOUT.t81 EAOUT.t178 VIN.t131 VIN.t26 pfet_06v0 ad=0.84p pd=3.56u as=0.84p ps=3.56u w=3u l=0.55u
X143 a_13132_25063# a_13612_15075# VSS.t46 ppolyf_u_1k_6p0 r_width=2u r_length=49.33u
X144 VIN.t76 EAOUT.t185 VOUT.t43 VIN.t28 pfet_06v0 ad=0.84p pd=3.56u as=0.84p ps=3.56u w=3u l=0.55u
X145 a_25710_9686.t3 a_25442_9686.t6 VIN.t275 VIN.t274 pfet_06v0 ad=3p pd=11.2u as=3p ps=11.2u w=5u l=3u
X146 a_11564_14636.t1 a_1786_3337# VIN.t264 VIN.t263 pfet_06v0 ad=1.4p pd=5.56u as=3p ps=11.2u w=5u l=0.6u
X147 VOUT.t64 EAOUT.t174 VIN.t97 VIN.t4 pfet_06v0 ad=0.84p pd=3.56u as=0.84p ps=3.56u w=3u l=0.55u
X148 a_25710_9686.t0 a_25442_9686.t7 VIN.t25 VIN.t24 pfet_06v0 ad=3p pd=11.2u as=3p ps=11.2u w=5u l=3u
X149 VIN.t184 EAOUT.t93 VOUT.t127 VIN.t144 pfet_06v0 ad=0.84p pd=3.56u as=0.84p ps=3.56u w=3u l=0.55u
X150 VOUT.t70 EAOUT.t10 VIN.t104 VIN.t65 pfet_06v0 ad=0.84p pd=3.56u as=0.84p ps=3.56u w=3u l=0.55u
X151 VSS.t32 VSS.t33 VSS.t31 ppolyf_u_1k_6p0 r_width=2u r_length=49.33u
X152 VOUT.t170 EAOUT.t152 VIN.t227 VIN.t142 pfet_06v0 ad=0.84p pd=3.56u as=0.84p ps=3.56u w=3u l=0.55u
X153 VIN.t170 EAOUT.t17 VOUT.t117 VIN.t6 pfet_06v0 ad=0.84p pd=3.56u as=0.84p ps=3.56u w=3u l=0.55u
X154 VOUT.t206 EAOUT.t136 VIN.t270 VIN.t34 pfet_06v0 ad=0.84p pd=3.56u as=0.84p ps=3.56u w=3u l=0.55u
X155 VIN.t100 EAOUT.t129 VOUT.t67 VIN.t8 pfet_06v0 ad=0.84p pd=3.56u as=0.84p ps=3.56u w=3u l=0.55u
X156 VOUT.t118 EAOUT.t108 VIN.t175 VIN.t36 pfet_06v0 ad=0.84p pd=3.56u as=0.84p ps=3.56u w=3u l=0.55u
X157 VIN.t194 EAOUT.t87 VOUT.t137 VIN.t43 pfet_06v0 ad=0.84p pd=3.56u as=0.84p ps=3.56u w=3u l=0.55u
X158 VIN.t149 EAOUT.t71 VOUT.t96 VIN.t22 pfet_06v0 ad=0.84p pd=3.56u as=0.84p ps=3.56u w=3u l=0.55u
X159 VOUT.t99 EAOUT.t66 VIN.t152 VIN.t2 pfet_06v0 ad=0.84p pd=3.56u as=1.8p ps=7.2u w=3u l=0.55u
X160 VIN.t210 EAOUT.t115 VOUT.t153 VIN.t51 pfet_06v0 ad=0.84p pd=3.56u as=0.84p ps=3.56u w=3u l=0.55u
X161 VSS.t71 VSS.t68 VSS.t70 VSS.t69 nfet_05v0 ad=1.45p pd=6.16u as=0 ps=0 w=2.5u l=0.6u
X162 VOUT.t105 EAOUT.t22 VIN.t158 VIN.t62 pfet_06v0 ad=0.84p pd=3.56u as=0.84p ps=3.56u w=3u l=0.55u
X163 VIN.t14 EAOUT.t43 VOUT.t6 VIN.t13 pfet_06v0 ad=0.84p pd=3.56u as=0.84p ps=3.56u w=3u l=0.55u
X164 VOUT.t87 EAOUT.t50 VIN.t138 VIN.t57 pfet_06v0 ad=0.84p pd=3.56u as=0.84p ps=3.56u w=3u l=0.55u
X165 VSS.t8 VSS.t9 VSS.t7 ppolyf_u_1k_6p0 r_width=2u r_length=49.33u
X166 VOUT.t165 EAOUT.t216 VIN.t222 VIN.t2 pfet_06v0 ad=0.84p pd=3.56u as=1.8p ps=7.2u w=3u l=0.55u
X167 VOUT.t75 EAOUT.t200 VIN.t125 VIN.t57 pfet_06v0 ad=0.84p pd=3.56u as=0.84p ps=3.56u w=3u l=0.55u
X168 VIN.t232 EAOUT.t193 VOUT.t175 VIN.t13 pfet_06v0 ad=0.84p pd=3.56u as=0.84p ps=3.56u w=3u l=0.55u
X169 VSS.t75 VSS.t72 VSS.t74 VSS.t73 nfet_06v0 ad=5.8p pd=21.16u as=0 ps=0 w=10u l=3u
X170 a_11564_14636.t0 a_18233_3337.t4 VSS.t29 ppolyf_u_1k_6p0 r_width=1u r_length=0.19609m
X171 VIN.t124 EAOUT.t167 VOUT.t74 VIN.t6 pfet_06v0 ad=0.84p pd=3.56u as=0.84p ps=3.56u w=3u l=0.55u
X172 VOUT.t46 EAOUT.t160 VIN.t79 VIN.t65 pfet_06v0 ad=0.84p pd=3.56u as=0.84p ps=3.56u w=3u l=0.55u
X173 VIN.t266 a_1786_3337# a_11564_14636.t2 VIN.t265 pfet_06v0 ad=3p pd=11.2u as=1.4p ps=5.56u w=5u l=0.6u
X174 a_16492_25063# a_17452_15075# VSS.t45 ppolyf_u_1k_6p0 r_width=2u r_length=49.33u
X175 VOUT.t62 EAOUT.t172 VIN.t95 VIN.t62 pfet_06v0 ad=0.84p pd=3.56u as=0.84p ps=3.56u w=3u l=0.55u
X176 VOUT.t136 EAOUT.t86 VIN.t193 VIN.t53 pfet_06v0 ad=0.84p pd=3.56u as=0.84p ps=3.56u w=3u l=0.55u
X177 VIN.t219 EAOUT.t79 VOUT.t162 VIN.t11 pfet_06v0 ad=0.84p pd=3.56u as=0.84p ps=3.56u w=3u l=0.55u
X178 VOUT.t180 EAOUT.t58 VIN.t237 VIN.t26 pfet_06v0 ad=0.84p pd=3.56u as=0.84p ps=3.56u w=3u l=0.55u
X179 VIN.t151 EAOUT.t65 VOUT.t98 VIN.t28 pfet_06v0 ad=0.84p pd=3.56u as=0.84p ps=3.56u w=3u l=0.55u
X180 VOUT.t0 EAOUT.t14 VIN.t1 VIN.t0 pfet_06v0 ad=0.84p pd=3.56u as=0.84p ps=3.56u w=3u l=0.55u
X181 VIN.t47 EAOUT.t21 VOUT.t21 VIN.t46 pfet_06v0 ad=0.84p pd=3.56u as=0.84p ps=3.56u w=3u l=0.55u
X182 VIN.t226 EAOUT.t215 VOUT.t169 VIN.t28 pfet_06v0 ad=0.84p pd=3.56u as=0.84p ps=3.56u w=3u l=0.55u
X183 VOUT.t83 EAOUT.t208 VIN.t134 VIN.t26 pfet_06v0 ad=0.84p pd=3.56u as=0.84p ps=3.56u w=3u l=0.55u
X184 VOUT.t54 EAOUT.t156 VIN.t87 VIN.t2 pfet_06v0 ad=0.84p pd=3.56u as=1.8p ps=7.2u w=3u l=0.55u
X185 VOUT.t30 EAOUT.t140 VIN.t60 VIN.t57 pfet_06v0 ad=0.84p pd=3.56u as=0.84p ps=3.56u w=3u l=0.55u
X186 VIN.t167 EAOUT.t133 VOUT.t114 VIN.t13 pfet_06v0 ad=0.84p pd=3.56u as=0.84p ps=3.56u w=3u l=0.55u
X187 VIN.t202 EAOUT.t91 VOUT.t145 VIN.t18 pfet_06v0 ad=0.84p pd=3.56u as=0.84p ps=3.56u w=3u l=0.55u
X188 VOUT.t93 EAOUT.t68 VIN.t146 VIN.t48 pfet_06v0 ad=0.84p pd=3.56u as=0.84p ps=3.56u w=3u l=0.55u
X189 VOUT.t20 a_17452_15075# VSS.t30 ppolyf_u_1k_6p0 r_width=2u r_length=49.33u
X190 VIN.t198 EAOUT.t119 VOUT.t141 VIN.t132 pfet_06v0 ad=0.84p pd=3.56u as=0.84p ps=3.56u w=3u l=0.55u
X191 VIN.t157 EAOUT.t75 VOUT.t104 VIN.t20 pfet_06v0 ad=0.84p pd=3.56u as=0.84p ps=3.56u w=3u l=0.55u
X192 VOUT.t212 EAOUT.t54 VIN.t278 VIN.t4 pfet_06v0 ad=0.84p pd=3.56u as=0.84p ps=3.56u w=3u l=0.55u
X193 VOUT.t193 EAOUT.t204 VIN.t252 VIN.t4 pfet_06v0 ad=0.84p pd=3.56u as=0.84p ps=3.56u w=3u l=0.55u
X194 VIN.t180 EAOUT.t97 VOUT.t123 VIN.t16 pfet_06v0 ad=1.8p pd=7.2u as=0.84p ps=3.56u w=3u l=0.55u
X195 a_16492_25063# a_15532_15075# VSS.t17 ppolyf_u_1k_6p0 r_width=2u r_length=49.33u
X196 a_644_14636.t4 a_1786_3337# VSS.t54 VSS.t53 nfet_05v0 ad=0.6p pd=3.2u as=0.6p ps=3.2u w=1u l=0.6u
X197 VIN.t116 VIN.t113 VIN.t115 VIN.t114 pfet_06v0 ad=2.9p pd=11.16u as=0 ps=0 w=5u l=3u
X198 VIN.t246 EAOUT.t171 VOUT.t189 VIN.t46 pfet_06v0 ad=0.84p pd=3.56u as=0.84p ps=3.56u w=3u l=0.55u
X199 VOUT.t71 EAOUT.t164 VIN.t121 VIN.t0 pfet_06v0 ad=0.84p pd=3.56u as=0.84p ps=3.56u w=3u l=0.55u
X200 a_16012_25063# FB VSS.t44 ppolyf_u_1k_6p0 r_width=2u r_length=49.33u
X201 VIN.t230 EAOUT.t155 VOUT.t173 VIN.t28 pfet_06v0 ad=0.84p pd=3.56u as=0.84p ps=3.56u w=3u l=0.55u
X202 VOUT.t197 EAOUT.t148 VIN.t256 VIN.t26 pfet_06v0 ad=0.84p pd=3.56u as=0.84p ps=3.56u w=3u l=0.55u
X203 VOUT.t144 EAOUT.t90 VIN.t201 VIN.t30 pfet_06v0 ad=0.84p pd=3.56u as=0.84p ps=3.56u w=3u l=0.55u
X204 VIN.t163 EAOUT.t83 VOUT.t110 VIN.t41 pfet_06v0 ad=0.84p pd=3.56u as=0.84p ps=3.56u w=3u l=0.55u
X205 a_25212_9686.t0 FB a_28055_3556.t5 VSS.t39 nfet_06v0 ad=6p pd=21.2u as=6p ps=21.2u w=10u l=3u
X206 VOUT.t202 a_1786_3337# VSS.t52 VSS.t51 nfet_05v0 ad=3p pd=11.2u as=3p ps=11.2u w=5u l=0.6u
X207 VOUT.t15 EAOUT.t18 VIN.t37 VIN.t36 pfet_06v0 ad=0.84p pd=3.56u as=0.84p ps=3.56u w=3u l=0.55u
X208 VIN.t172 a_3623_3336.t2 EAOUT.t4 VIN.t171 pfet_06v0 ad=3p pd=11.2u as=3p ps=11.2u w=5u l=0.6u
X209 VIN.t164 EAOUT.t25 VOUT.t111 VIN.t51 pfet_06v0 ad=0.84p pd=3.56u as=0.84p ps=3.56u w=3u l=0.55u
X210 VOUT.t23 EAOUT.t144 VIN.t50 VIN.t4 pfet_06v0 ad=0.84p pd=3.56u as=0.84p ps=3.56u w=3u l=0.55u
X211 VOUT.t34 EAOUT.t40 VIN.t66 VIN.t65 pfet_06v0 ad=0.84p pd=3.56u as=0.84p ps=3.56u w=3u l=0.55u
X212 VIN.t7 EAOUT.t47 VOUT.t3 VIN.t6 pfet_06v0 ad=0.84p pd=3.56u as=0.84p ps=3.56u w=3u l=0.55u
X213 VOUT.t52 EAOUT.t190 VIN.t85 VIN.t65 pfet_06v0 ad=0.84p pd=3.56u as=0.84p ps=3.56u w=3u l=0.55u
X214 VIN.t206 EAOUT.t123 VOUT.t149 VIN.t144 pfet_06v0 ad=0.84p pd=3.56u as=0.84p ps=3.56u w=3u l=0.55u
X215 VIN.t92 EAOUT.t197 VOUT.t59 VIN.t6 pfet_06v0 ad=0.84p pd=3.56u as=0.84p ps=3.56u w=3u l=0.55u
X216 VIN.t196 EAOUT.t117 VOUT.t139 VIN.t43 pfet_06v0 ad=0.84p pd=3.56u as=0.84p ps=3.56u w=3u l=0.55u
X217 a_28055_3556.t1 a_18233_3337.t7 VSS.t6 VSS.t5 nfet_05v0 ad=1.5p pd=6.2u as=1.5p ps=6.2u w=2.5u l=0.6u
X218 a_18233_3337.t1 a_18233_3337.t0 VSS.t37 VSS.t36 nfet_05v0 ad=1.5p pd=6.2u as=1.5p ps=6.2u w=2.5u l=0.6u
X219 VIN.t188 EAOUT.t101 VOUT.t131 VIN.t22 pfet_06v0 ad=0.84p pd=3.56u as=0.84p ps=3.56u w=3u l=0.55u
X220 VIN.t108 VIN.t105 VIN.t107 VIN.t106 pfet_06v0 ad=1.45p pd=6.16u as=0 ps=0 w=2.5u l=0.55u
X221 VOUT.t210 EAOUT.t52 VIN.t276 VIN.t62 pfet_06v0 ad=0.84p pd=3.56u as=0.84p ps=3.56u w=3u l=0.55u
X222 VOUT.t77 EAOUT.t202 VIN.t127 VIN.t62 pfet_06v0 ad=0.84p pd=3.56u as=0.84p ps=3.56u w=3u l=0.55u
X223 a_25442_9686.t0 a_25212_9686.t4 a_25212_9686.t5 VIN.t15 pfet_06v0 ad=1.5p pd=6.2u as=1.5p ps=6.2u w=2.5u l=0.55u
X224 VIN.t98 EAOUT.t175 VOUT.t65 VIN.t51 pfet_06v0 ad=0.84p pd=3.56u as=0.84p ps=3.56u w=3u l=0.55u
X225 VOUT.t186 EAOUT.t168 VIN.t243 VIN.t36 pfet_06v0 ad=0.84p pd=3.56u as=0.84p ps=3.56u w=3u l=0.55u
X226 a_25442_9686.t1 a_25212_9686.t2 a_25212_9686.t3 VIN.t32 pfet_06v0 ad=1.5p pd=6.2u as=1.5p ps=6.2u w=2.5u l=0.55u
X227 VOUT.t128 EAOUT.t94 VIN.t185 VIN.t68 pfet_06v0 ad=0.84p pd=3.56u as=0.84p ps=3.56u w=3u l=0.55u
X228 VIN.t112 VIN.t109 VIN.t111 VIN.t110 pfet_06v0 ad=1.45p pd=6.16u as=0 ps=0 w=2.5u l=0.55u
X229 a_25442_9686.t3 a_25442_9686.t2 VIN.t250 VIN.t249 pfet_06v0 ad=3p pd=11.2u as=3p ps=11.2u w=5u l=3u
X230 a_1786_3337# VSS.t80 VIN.t269 VIN.t268 pfet_06v0 ad=0.6p pd=3.2u as=0.6p ps=3.2u w=1u l=40u
X231 VIN.t165 EAOUT.t29 VOUT.t112 VIN.t132 pfet_06v0 ad=0.84p pd=3.56u as=0.84p ps=3.56u w=3u l=0.55u
X232 VIN.t271 EAOUT.t137 VOUT.t207 VIN.t6 pfet_06v0 ad=0.84p pd=3.56u as=0.84p ps=3.56u w=3u l=0.55u
X233 VOUT.t68 EAOUT.t130 VIN.t101 VIN.t65 pfet_06v0 ad=0.84p pd=3.56u as=0.84p ps=3.56u w=3u l=0.55u
X234 VIN.t176 EAOUT.t109 VOUT.t119 VIN.t11 pfet_06v0 ad=0.84p pd=3.56u as=0.84p ps=3.56u w=3u l=0.55u
X235 VOUT.t101 EAOUT.t72 VIN.t154 VIN.t39 pfet_06v0 ad=0.84p pd=3.56u as=0.84p ps=3.56u w=3u l=0.55u
X236 VOUT.t138 EAOUT.t116 VIN.t195 VIN.t53 pfet_06v0 ad=0.84p pd=3.56u as=0.84p ps=3.56u w=3u l=0.55u
X237 VIN.t17 EAOUT.t7 VOUT.t7 VIN.t16 pfet_06v0 ad=1.8p pd=7.2u as=0.84p ps=3.56u w=3u l=0.55u
X238 VOUT.t35 EAOUT.t44 VIN.t67 VIN.t0 pfet_06v0 ad=0.84p pd=3.56u as=0.84p ps=3.56u w=3u l=0.55u
X239 VIN.t139 EAOUT.t51 VOUT.t88 VIN.t46 pfet_06v0 ad=0.84p pd=3.56u as=0.84p ps=3.56u w=3u l=0.55u
X240 VIN.t126 EAOUT.t201 VOUT.t76 VIN.t46 pfet_06v0 ad=0.84p pd=3.56u as=0.84p ps=3.56u w=3u l=0.55u
X241 VOUT.t176 EAOUT.t194 VIN.t233 VIN.t0 pfet_06v0 ad=0.84p pd=3.56u as=0.84p ps=3.56u w=3u l=0.55u
X242 VOUT.t32 EAOUT.t142 VIN.t63 VIN.t62 pfet_06v0 ad=0.84p pd=3.56u as=0.84p ps=3.56u w=3u l=0.55u
X243 VIN.t204 EAOUT.t121 VOUT.t147 VIN.t18 pfet_06v0 ad=0.84p pd=3.56u as=0.84p ps=3.56u w=3u l=0.55u
X244 VIN.t213 EAOUT.t105 VOUT.t156 VIN.t20 pfet_06v0 ad=0.84p pd=3.56u as=0.84p ps=3.56u w=3u l=0.55u
X245 VOUT.t124 EAOUT.t98 VIN.t181 VIN.t48 pfet_06v0 ad=0.84p pd=3.56u as=0.84p ps=3.56u w=3u l=0.55u
X246 a_3623_3336.t1 a_1786_3337# VSS.t50 VSS.t49 nfet_05v0 ad=3p pd=11.2u as=3p ps=11.2u w=5u l=0.6u
X247 VIN.t133 EAOUT.t179 VOUT.t82 VIN.t132 pfet_06v0 ad=0.84p pd=3.56u as=0.84p ps=3.56u w=3u l=0.55u
X248 VIN.t88 EAOUT.t157 VOUT.t55 VIN.t16 pfet_06v0 ad=1.8p pd=7.2u as=0.84p ps=3.56u w=3u l=0.55u
X249 VIN.t61 EAOUT.t141 VOUT.t31 VIN.t46 pfet_06v0 ad=0.84p pd=3.56u as=0.84p ps=3.56u w=3u l=0.55u
X250 VOUT.t115 EAOUT.t134 VIN.t168 VIN.t0 pfet_06v0 ad=0.84p pd=3.56u as=0.84p ps=3.56u w=3u l=0.55u
X251 VOUT.t126 EAOUT.t92 VIN.t183 VIN.t142 pfet_06v0 ad=0.84p pd=3.56u as=0.84p ps=3.56u w=3u l=0.55u
X252 VIN.t147 EAOUT.t69 VOUT.t94 VIN.t8 pfet_06v0 ad=0.84p pd=3.56u as=0.84p ps=3.56u w=3u l=0.55u
X253 VIN.t221 EAOUT.t33 VOUT.t164 VIN.t144 pfet_06v0 ad=0.84p pd=3.56u as=0.84p ps=3.56u w=3u l=0.55u
X254 VOUT.t146 EAOUT.t120 VIN.t203 VIN.t30 pfet_06v0 ad=0.84p pd=3.56u as=0.84p ps=3.56u w=3u l=0.55u
X255 VIN.t208 EAOUT.t113 VOUT.t151 VIN.t41 pfet_06v0 ad=0.84p pd=3.56u as=0.84p ps=3.56u w=3u l=0.55u
X256 VOUT.t159 EAOUT.t76 VIN.t216 VIN.t34 pfet_06v0 ad=0.84p pd=3.56u as=0.84p ps=3.56u w=3u l=0.55u
X257 VIN.t44 EAOUT.t27 VOUT.t19 VIN.t43 pfet_06v0 ad=0.84p pd=3.56u as=0.84p ps=3.56u w=3u l=0.55u
X258 VOUT.t27 EAOUT.t48 VIN.t56 VIN.t36 pfet_06v0 ad=0.84p pd=3.56u as=0.84p ps=3.56u w=3u l=0.55u
X259 VIN.t279 EAOUT.t55 VOUT.t213 VIN.t51 pfet_06v0 ad=0.84p pd=3.56u as=0.84p ps=3.56u w=3u l=0.55u
X260 VIN.t23 EAOUT.t11 VOUT.t10 VIN.t22 pfet_06v0 ad=0.84p pd=3.56u as=0.84p ps=3.56u w=3u l=0.55u
X261 VIN.t253 EAOUT.t205 VOUT.t194 VIN.t51 pfet_06v0 ad=0.84p pd=3.56u as=0.84p ps=3.56u w=3u l=0.55u
X262 VOUT.t60 EAOUT.t198 VIN.t93 VIN.t36 pfet_06v0 ad=0.84p pd=3.56u as=0.84p ps=3.56u w=3u l=0.55u
X263 VIN.t242 EAOUT.t183 VOUT.t185 VIN.t144 pfet_06v0 ad=0.84p pd=3.56u as=0.84p ps=3.56u w=3u l=0.55u
X264 VIN.t103 FB FB_BUF.t2 VSS.t38 nfet_05v0 ad=3p pd=11.2u as=3p ps=11.2u w=5u l=0.6u
X265 a_25442_9686.t5 a_25442_9686.t4 VIN.t174 VIN.t173 pfet_06v0 ad=3p pd=11.2u as=3p ps=11.2u w=5u l=3u
X266 a_644_14636.t1 a_644_14636.t0 VSS.t15 VSS.t14 nfet_05v0 ad=1.5p pd=6.2u as=1.5p ps=6.2u w=2.5u l=0.6u
X267 EAOUT_BUF.t1 a_644_14636.t9 VSS.t13 VSS.t12 nfet_05v0 ad=1.5p pd=6.2u as=1.5p ps=6.2u w=2.5u l=0.6u
X268 a_16012_25063# a_15052_15075# VSS.t43 ppolyf_u_1k_6p0 r_width=2u r_length=49.33u
X269 VIN.t130 EAOUT.t177 VOUT.t80 VIN.t43 pfet_06v0 ad=0.84p pd=3.56u as=0.84p ps=3.56u w=3u l=0.55u
C0 a_1786_3337# VIN 10.7265f
C1 VIN VOUT 0.21686p
C2 a_13612_15075# a_15052_15075# 0.10341f
C3 a_14092_25063# a_14572_25063# 0.55839f
C4 EAOUT a_1786_3337# 1.45986f
C5 EAOUT VOUT 57.0214f
C6 VREF FB 1.18842f
C7 EAOUT_BUF FB 0.09857f
C8 VOUT a_16492_25063# 0.10952f
C9 a_17452_15075# VOUT 0.00344f
C10 VOUT a_16012_25063# 0
C11 a_13132_25063# a_14092_25063# 0.10341f
C12 VIN FB 1.24533f
C13 VIN EAOUT_BUF 1.98345f
C14 EAOUT FB 1.56796f
C15 EAOUT VREF 1.14534f
C16 a_1786_3337# FB_BUF 0.07719f
C17 EAOUT EAOUT_BUF 0.15116f
C18 VOUT FB_BUF 0.00151f
C19 a_17452_15075# FB 0.09449f
C20 EAOUT VIN 0.1012p
C21 FB a_15532_15075# 0.10952f
C22 FB a_15052_15075# 0
C23 a_17452_15075# EAOUT 0.00412f
C24 FB_BUF FB 1.0839f
C25 FB a_13612_15075# 0.09449f
C26 a_1786_3337# VOUT 0.47264f
C27 FB_BUF EAOUT_BUF 3.43406f
C28 a_16012_25063# a_16492_25063# 0.55839f
C29 a_17452_15075# a_15532_15075# 0
C30 VIN FB_BUF 1.70832f
C31 a_17452_15075# a_15052_15075# 0.00328f
C32 EAOUT FB_BUF 0.01355f
C33 a_1786_3337# EN 0.05086f
C34 a_14572_25063# a_16492_25063# 0.01219f
C35 a_15052_15075# a_15532_15075# 0.55839f
C36 a_1786_3337# FB 4.06353f
C37 VOUT FB 0.06759f
C38 a_14572_25063# a_16012_25063# 0.09449f
C39 a_1786_3337# EAOUT_BUF 1.42912f
C40 VOUT EAOUT_BUF 0.00426f
C41 a_14092_25063# a_16012_25063# 0.00488f
R0 VREF VREF.n0 21.5859
R1 VREF.n0 VREF.t0 21.7345
R2 VREF.n0 VREF.t1 20.9422
R3 EAOUT_BUF.n0 EAOUT_BUF.t0 23.7518
R4 EAOUT_BUF EAOUT_BUF.n0 18.4911
R5 EAOUT_BUF.n0 EAOUT_BUF.n1 12.2002
R6 EAOUT_BUF.n1 EAOUT_BUF.t2 8.74382
R7 EAOUT_BUF.n1 EAOUT_BUF.t1 9.03362
R8 FB_BUF.n0 FB_BUF.t2 26.5987
R9 FB_BUF FB_BUF.n0 16.8753
R10 FB_BUF.n0 FB_BUF.n1 11.963
R11 FB_BUF.n1 FB_BUF.t1 8.16637
R12 FB_BUF.n1 FB_BUF.t0 8.62357
R13 EN EN.t0 26.2602
R14 VOUT VOUT.n2 0.0171667
R15 VOUT.n2 VOUT.n3 0.104367
R16 VOUT.n3 VOUT.n4 0.0431667
R17 VOUT.n4 VOUT.n5 0.0431667
R18 VOUT.n5 VOUT.n6 0.0431667
R19 VOUT.n7 VOUT.n79 1.8005
R20 VOUT.n8 VOUT.n114 1.8005
R21 VOUT.n9 VOUT.n146 1.8005
R22 VOUT.n10 VOUT.n176 1.8005
R23 VOUT.n11 VOUT.n204 1.8005
R24 VOUT.n12 VOUT.n231 1.8005
R25 VOUT.n11 VOUT.n12 0.214769
R26 VOUT.n10 VOUT.n11 0.214769
R27 VOUT.n9 VOUT.n10 0.214769
R28 VOUT.n8 VOUT.n9 0.214769
R29 VOUT.n7 VOUT.n8 0.214769
R30 VOUT.n6 VOUT.n7 0.848446
R31 VOUT.n12 VOUT.n279 2.01477
R32 VOUT.n142 VOUT.n19 2.01477
R33 VOUT.n173 VOUT.n20 2.01477
R34 VOUT.n202 VOUT.n21 2.01477
R35 VOUT.n230 VOUT.n22 2.01477
R36 VOUT.n255 VOUT.n14 6.1745
R37 VOUT.n16 VOUT.n14 0.4001
R38 VOUT.n19 VOUT.n16 0.3461
R39 VOUT.n19 VOUT.n18 0.0545
R40 VOUT.n18 VOUT.n257 0.4001
R41 VOUT.n257 VOUT.n259 0.4001
R42 VOUT.n20 VOUT.n259 0.2993
R43 VOUT.n20 VOUT.n261 0.1013
R44 VOUT.n261 VOUT.n263 0.4001
R45 VOUT.n263 VOUT.n265 0.4001
R46 VOUT.n21 VOUT.n265 0.2525
R47 VOUT.n21 VOUT.n267 0.1481
R48 VOUT.n267 VOUT.n269 0.4001
R49 VOUT.n269 VOUT.n271 0.4001
R50 VOUT.n22 VOUT.n271 0.2057
R51 VOUT.n22 VOUT.n273 0.1949
R52 VOUT.n273 VOUT.n275 0.4001
R53 VOUT.n275 VOUT.n277 0.4001
R54 VOUT.n279 VOUT.n277 0.1589
R55 VOUT.n279 VOUT.n278 6.36695
R56 VOUT.n278 VOUT.t190 0.653833
R57 VOUT.n278 VOUT.t7 0.653833
R58 VOUT.n277 VOUT.n276 6.12575
R59 VOUT.n276 VOUT.t70 0.653833
R60 VOUT.n276 VOUT.t4 0.653833
R61 VOUT.n275 VOUT.n274 6.12575
R62 VOUT.n274 VOUT.t41 0.653833
R63 VOUT.n274 VOUT.t10 0.653833
R64 VOUT.n273 VOUT.n272 6.12575
R65 VOUT.n272 VOUT.t0 0.653833
R66 VOUT.n272 VOUT.t40 0.653833
R67 VOUT.n271 VOUT.n270 6.12575
R68 VOUT.n270 VOUT.t14 0.653833
R69 VOUT.n270 VOUT.t9 0.653833
R70 VOUT.n269 VOUT.n268 6.12575
R71 VOUT.n268 VOUT.t15 0.653833
R72 VOUT.n268 VOUT.t117 0.653833
R73 VOUT.n267 VOUT.n266 6.12575
R74 VOUT.n266 VOUT.t28 0.653833
R75 VOUT.n266 VOUT.t5 0.653833
R76 VOUT.n265 VOUT.n264 6.12575
R77 VOUT.n264 VOUT.t105 0.653833
R78 VOUT.n264 VOUT.t21 0.653833
R79 VOUT.n263 VOUT.n262 6.12575
R80 VOUT.n262 VOUT.t2 0.653833
R81 VOUT.n262 VOUT.t18 0.653833
R82 VOUT.n261 VOUT.n260 6.12575
R83 VOUT.n260 VOUT.t201 0.653833
R84 VOUT.n260 VOUT.t111 0.653833
R85 VOUT.n259 VOUT.n258 6.12575
R86 VOUT.n258 VOUT.t11 0.653833
R87 VOUT.n258 VOUT.t19 0.653833
R88 VOUT.n257 VOUT.n256 6.12575
R89 VOUT.n256 VOUT.t13 0.653833
R90 VOUT.n256 VOUT.t112 0.653833
R91 VOUT.n255 VOUT.n26 1.1147
R92 VOUT.n26 VOUT.n25 1.1147
R93 VOUT.n25 VOUT.n24 1.1147
R94 VOUT.n24 VOUT.n23 1.1147
R95 VOUT.n142 VOUT.n33 1.8005
R96 VOUT.n173 VOUT.n34 1.8005
R97 VOUT.n202 VOUT.n35 1.8005
R98 VOUT.n28 VOUT.n255 5.0603
R99 VOUT.n30 VOUT.n28 0.4001
R100 VOUT.n33 VOUT.n30 0.3461
R101 VOUT.n33 VOUT.n32 0.0545
R102 VOUT.n32 VOUT.n233 0.4001
R103 VOUT.n233 VOUT.n235 0.4001
R104 VOUT.n34 VOUT.n235 0.2993
R105 VOUT.n34 VOUT.n237 0.1013
R106 VOUT.n237 VOUT.n239 0.4001
R107 VOUT.n239 VOUT.n241 0.4001
R108 VOUT.n35 VOUT.n241 0.2525
R109 VOUT.n35 VOUT.n243 0.1481
R110 VOUT.n243 VOUT.n245 0.4001
R111 VOUT.n245 VOUT.n247 0.4001
R112 VOUT.n36 VOUT.n247 0.2057
R113 VOUT.n36 VOUT.n249 0.1949
R114 VOUT.n249 VOUT.n251 0.4001
R115 VOUT.n251 VOUT.n253 0.4001
R116 VOUT.n231 VOUT.n253 0.1589
R117 VOUT.n231 VOUT.n254 6.36695
R118 VOUT.n254 VOUT.t22 0.653833
R119 VOUT.n254 VOUT.t163 0.653833
R120 VOUT.n253 VOUT.n252 6.12575
R121 VOUT.n252 VOUT.t34 0.653833
R122 VOUT.n252 VOUT.t16 0.653833
R123 VOUT.n251 VOUT.n250 6.12575
R124 VOUT.n250 VOUT.t17 0.653833
R125 VOUT.n250 VOUT.t106 0.653833
R126 VOUT.n249 VOUT.n248 6.12575
R127 VOUT.n248 VOUT.t35 0.653833
R128 VOUT.n248 VOUT.t6 0.653833
R129 VOUT.n247 VOUT.n246 6.12575
R130 VOUT.n246 VOUT.t29 0.653833
R131 VOUT.n246 VOUT.t154 0.653833
R132 VOUT.n245 VOUT.n244 6.12575
R133 VOUT.n244 VOUT.t27 0.653833
R134 VOUT.n244 VOUT.t3 0.653833
R135 VOUT.n243 VOUT.n242 6.12575
R136 VOUT.n242 VOUT.t87 0.653833
R137 VOUT.n242 VOUT.t192 0.653833
R138 VOUT.n241 VOUT.n240 6.12575
R139 VOUT.n240 VOUT.t210 0.653833
R140 VOUT.n240 VOUT.t88 0.653833
R141 VOUT.n239 VOUT.n238 6.12575
R142 VOUT.n238 VOUT.t212 0.653833
R143 VOUT.n238 VOUT.t211 0.653833
R144 VOUT.n237 VOUT.n236 6.12575
R145 VOUT.n236 VOUT.t178 0.653833
R146 VOUT.n236 VOUT.t213 0.653833
R147 VOUT.n235 VOUT.n234 6.12575
R148 VOUT.n234 VOUT.t180 0.653833
R149 VOUT.n234 VOUT.t179 0.653833
R150 VOUT.n233 VOUT.n232 6.12575
R151 VOUT.n232 VOUT.t89 0.653833
R152 VOUT.n232 VOUT.t181 0.653833
R153 VOUT.n230 VOUT.n36 1.8005
R154 VOUT.n37 VOUT.n78 1.8005
R155 VOUT.n38 VOUT.n113 1.8005
R156 VOUT.n39 VOUT.n145 1.8005
R157 VOUT.n40 VOUT.n175 1.8005
R158 VOUT.n229 VOUT.n230 0.214769
R159 VOUT.n40 VOUT.n229 0.214769
R160 VOUT.n39 VOUT.n40 0.214769
R161 VOUT.n38 VOUT.n39 0.214769
R162 VOUT.n37 VOUT.n38 0.214769
R163 VOUT.n6 VOUT.n37 0.80578
R164 VOUT.n229 VOUT.n228 1.8005
R165 VOUT.n141 VOUT.n47 1.8005
R166 VOUT.n172 VOUT.n48 1.8005
R167 VOUT.n42 VOUT.n26 5.0603
R168 VOUT.n44 VOUT.n42 0.4001
R169 VOUT.n47 VOUT.n44 0.3461
R170 VOUT.n47 VOUT.n46 0.0545
R171 VOUT.n46 VOUT.n206 0.4001
R172 VOUT.n206 VOUT.n208 0.4001
R173 VOUT.n48 VOUT.n208 0.2993
R174 VOUT.n48 VOUT.n210 0.1013
R175 VOUT.n210 VOUT.n212 0.4001
R176 VOUT.n212 VOUT.n214 0.4001
R177 VOUT.n49 VOUT.n214 0.2525
R178 VOUT.n49 VOUT.n216 0.1481
R179 VOUT.n216 VOUT.n218 0.4001
R180 VOUT.n218 VOUT.n220 0.4001
R181 VOUT.n228 VOUT.n220 0.2057
R182 VOUT.n228 VOUT.n222 0.1949
R183 VOUT.n222 VOUT.n224 0.4001
R184 VOUT.n224 VOUT.n226 0.4001
R185 VOUT.n204 VOUT.n226 0.1589
R186 VOUT.n204 VOUT.n227 6.36695
R187 VOUT.n227 VOUT.t93 0.653833
R188 VOUT.n227 VOUT.t100 0.653833
R189 VOUT.n226 VOUT.n225 6.12575
R190 VOUT.n225 VOUT.t95 0.653833
R191 VOUT.n225 VOUT.t94 0.653833
R192 VOUT.n224 VOUT.n223 6.12575
R193 VOUT.n223 VOUT.t101 0.653833
R194 VOUT.n223 VOUT.t96 0.653833
R195 VOUT.n222 VOUT.n221 6.12575
R196 VOUT.n221 VOUT.t103 0.653833
R197 VOUT.n221 VOUT.t102 0.653833
R198 VOUT.n220 VOUT.n219 6.12575
R199 VOUT.n219 VOUT.t159 0.653833
R200 VOUT.n219 VOUT.t104 0.653833
R201 VOUT.n218 VOUT.n217 6.12575
R202 VOUT.n217 VOUT.t161 0.653833
R203 VOUT.n217 VOUT.t160 0.653833
R204 VOUT.n216 VOUT.n215 6.12575
R205 VOUT.n215 VOUT.t107 0.653833
R206 VOUT.n215 VOUT.t162 0.653833
R207 VOUT.n214 VOUT.n213 6.12575
R208 VOUT.n213 VOUT.t109 0.653833
R209 VOUT.n213 VOUT.t108 0.653833
R210 VOUT.n212 VOUT.n211 6.12575
R211 VOUT.n211 VOUT.t134 0.653833
R212 VOUT.n211 VOUT.t110 0.653833
R213 VOUT.n210 VOUT.n209 6.12575
R214 VOUT.n209 VOUT.t136 0.653833
R215 VOUT.n209 VOUT.t135 0.653833
R216 VOUT.n208 VOUT.n207 6.12575
R217 VOUT.n207 VOUT.t142 0.653833
R218 VOUT.n207 VOUT.t137 0.653833
R219 VOUT.n206 VOUT.n205 6.12575
R220 VOUT.n205 VOUT.t144 0.653833
R221 VOUT.n205 VOUT.t143 0.653833
R222 VOUT.n203 VOUT.n49 1.8005
R223 VOUT.n50 VOUT.n77 1.8005
R224 VOUT.n51 VOUT.n112 1.8005
R225 VOUT.n52 VOUT.n144 1.8005
R226 VOUT.n203 VOUT.n202 0.214769
R227 VOUT.n201 VOUT.n203 0.214769
R228 VOUT.n52 VOUT.n201 0.214769
R229 VOUT.n51 VOUT.n52 0.214769
R230 VOUT.n50 VOUT.n51 0.214769
R231 VOUT.n5 VOUT.n50 0.80578
R232 VOUT.n201 VOUT.n200 1.8005
R233 VOUT.n140 VOUT.n59 1.8005
R234 VOUT.n54 VOUT.n25 5.0603
R235 VOUT.n56 VOUT.n54 0.4001
R236 VOUT.n59 VOUT.n56 0.3461
R237 VOUT.n59 VOUT.n58 0.0545
R238 VOUT.n58 VOUT.n178 0.4001
R239 VOUT.n178 VOUT.n180 0.4001
R240 VOUT.n60 VOUT.n180 0.2993
R241 VOUT.n60 VOUT.n182 0.1013
R242 VOUT.n182 VOUT.n184 0.4001
R243 VOUT.n184 VOUT.n186 0.4001
R244 VOUT.n200 VOUT.n186 0.2525
R245 VOUT.n200 VOUT.n188 0.1481
R246 VOUT.n188 VOUT.n190 0.4001
R247 VOUT.n190 VOUT.n192 0.4001
R248 VOUT.n175 VOUT.n192 0.2057
R249 VOUT.n175 VOUT.n194 0.1949
R250 VOUT.n194 VOUT.n196 0.4001
R251 VOUT.n196 VOUT.n198 0.4001
R252 VOUT.n176 VOUT.n198 0.1589
R253 VOUT.n176 VOUT.n199 6.36695
R254 VOUT.n199 VOUT.t124 0.653833
R255 VOUT.n199 VOUT.t123 0.653833
R256 VOUT.n198 VOUT.n197 6.12575
R257 VOUT.n197 VOUT.t130 0.653833
R258 VOUT.n197 VOUT.t125 0.653833
R259 VOUT.n196 VOUT.n195 6.12575
R260 VOUT.n195 VOUT.t132 0.653833
R261 VOUT.n195 VOUT.t131 0.653833
R262 VOUT.n194 VOUT.n193 6.12575
R263 VOUT.n193 VOUT.t155 0.653833
R264 VOUT.n193 VOUT.t133 0.653833
R265 VOUT.n192 VOUT.n191 6.12575
R266 VOUT.n191 VOUT.t157 0.653833
R267 VOUT.n191 VOUT.t156 0.653833
R268 VOUT.n190 VOUT.n189 6.12575
R269 VOUT.n189 VOUT.t118 0.653833
R270 VOUT.n189 VOUT.t158 0.653833
R271 VOUT.n188 VOUT.n187 6.12575
R272 VOUT.n187 VOUT.t120 0.653833
R273 VOUT.n187 VOUT.t119 0.653833
R274 VOUT.n186 VOUT.n185 6.12575
R275 VOUT.n185 VOUT.t150 0.653833
R276 VOUT.n185 VOUT.t121 0.653833
R277 VOUT.n184 VOUT.n183 6.12575
R278 VOUT.n183 VOUT.t152 0.653833
R279 VOUT.n183 VOUT.t151 0.653833
R280 VOUT.n182 VOUT.n181 6.12575
R281 VOUT.n181 VOUT.t138 0.653833
R282 VOUT.n181 VOUT.t153 0.653833
R283 VOUT.n180 VOUT.n179 6.12575
R284 VOUT.n179 VOUT.t140 0.653833
R285 VOUT.n179 VOUT.t139 0.653833
R286 VOUT.n178 VOUT.n177 6.12575
R287 VOUT.n177 VOUT.t146 0.653833
R288 VOUT.n177 VOUT.t141 0.653833
R289 VOUT.n174 VOUT.n60 1.8005
R290 VOUT.n61 VOUT.n76 1.8005
R291 VOUT.n62 VOUT.n111 1.8005
R292 VOUT.n172 VOUT.n173 0.214769
R293 VOUT.n174 VOUT.n172 0.214769
R294 VOUT.n171 VOUT.n174 0.214769
R295 VOUT.n62 VOUT.n171 0.214769
R296 VOUT.n61 VOUT.n62 0.214769
R297 VOUT.n4 VOUT.n61 0.80578
R298 VOUT.n171 VOUT.n170 1.8005
R299 VOUT.n64 VOUT.n24 5.0603
R300 VOUT.n66 VOUT.n64 0.4001
R301 VOUT.n69 VOUT.n66 0.3461
R302 VOUT.n69 VOUT.n68 0.0545
R303 VOUT.n68 VOUT.n148 0.4001
R304 VOUT.n148 VOUT.n150 0.4001
R305 VOUT.n170 VOUT.n150 0.2993
R306 VOUT.n170 VOUT.n152 0.1013
R307 VOUT.n152 VOUT.n154 0.4001
R308 VOUT.n154 VOUT.n156 0.4001
R309 VOUT.n144 VOUT.n156 0.2525
R310 VOUT.n144 VOUT.n158 0.1481
R311 VOUT.n158 VOUT.n160 0.4001
R312 VOUT.n160 VOUT.n162 0.4001
R313 VOUT.n145 VOUT.n162 0.2057
R314 VOUT.n145 VOUT.n164 0.1949
R315 VOUT.n164 VOUT.n166 0.4001
R316 VOUT.n166 VOUT.n168 0.4001
R317 VOUT.n146 VOUT.n168 0.1589
R318 VOUT.n146 VOUT.n169 6.36695
R319 VOUT.n169 VOUT.t66 0.653833
R320 VOUT.n169 VOUT.t39 0.653833
R321 VOUT.n168 VOUT.n167 6.12575
R322 VOUT.n167 VOUT.t68 0.653833
R323 VOUT.n167 VOUT.t67 0.653833
R324 VOUT.n166 VOUT.n165 6.12575
R325 VOUT.n165 VOUT.t113 0.653833
R326 VOUT.n165 VOUT.t69 0.653833
R327 VOUT.n164 VOUT.n163 6.12575
R328 VOUT.n163 VOUT.t115 0.653833
R329 VOUT.n163 VOUT.t114 0.653833
R330 VOUT.n162 VOUT.n161 6.12575
R331 VOUT.n161 VOUT.t206 0.653833
R332 VOUT.n161 VOUT.t116 0.653833
R333 VOUT.n160 VOUT.n159 6.12575
R334 VOUT.n159 VOUT.t208 0.653833
R335 VOUT.n159 VOUT.t207 0.653833
R336 VOUT.n158 VOUT.n157 6.12575
R337 VOUT.n157 VOUT.t30 0.653833
R338 VOUT.n157 VOUT.t209 0.653833
R339 VOUT.n156 VOUT.n155 6.12575
R340 VOUT.n155 VOUT.t32 0.653833
R341 VOUT.n155 VOUT.t31 0.653833
R342 VOUT.n154 VOUT.n153 6.12575
R343 VOUT.n153 VOUT.t23 0.653833
R344 VOUT.n153 VOUT.t33 0.653833
R345 VOUT.n152 VOUT.n151 6.12575
R346 VOUT.n151 VOUT.t25 0.653833
R347 VOUT.n151 VOUT.t24 0.653833
R348 VOUT.n150 VOUT.n149 6.12575
R349 VOUT.n149 VOUT.t197 0.653833
R350 VOUT.n149 VOUT.t26 0.653833
R351 VOUT.n148 VOUT.n147 6.12575
R352 VOUT.n147 VOUT.t199 0.653833
R353 VOUT.n147 VOUT.t198 0.653833
R354 VOUT.n143 VOUT.n69 1.8005
R355 VOUT.n141 VOUT.n142 0.214769
R356 VOUT.n140 VOUT.n141 0.214769
R357 VOUT.n143 VOUT.n140 0.214769
R358 VOUT.n139 VOUT.n143 0.214769
R359 VOUT.n104 VOUT.n139 0.214769
R360 VOUT.n3 VOUT.n104 0.80578
R361 VOUT.n139 VOUT.n138 1.8005
R362 VOUT.n106 VOUT.n23 5.0603
R363 VOUT.n108 VOUT.n106 0.4001
R364 VOUT.n138 VOUT.n108 0.3461
R365 VOUT.n138 VOUT.n110 0.0545
R366 VOUT.n110 VOUT.n116 0.4001
R367 VOUT.n116 VOUT.n118 0.4001
R368 VOUT.n111 VOUT.n118 0.2993
R369 VOUT.n111 VOUT.n120 0.1013
R370 VOUT.n120 VOUT.n122 0.4001
R371 VOUT.n122 VOUT.n124 0.4001
R372 VOUT.n112 VOUT.n124 0.2525
R373 VOUT.n112 VOUT.n126 0.1481
R374 VOUT.n126 VOUT.n128 0.4001
R375 VOUT.n128 VOUT.n130 0.4001
R376 VOUT.n113 VOUT.n130 0.2057
R377 VOUT.n113 VOUT.n132 0.1949
R378 VOUT.n132 VOUT.n134 0.4001
R379 VOUT.n134 VOUT.n136 0.4001
R380 VOUT.n114 VOUT.n136 0.1589
R381 VOUT.n114 VOUT.n137 6.36695
R382 VOUT.n137 VOUT.t56 0.653833
R383 VOUT.n137 VOUT.t55 0.653833
R384 VOUT.n136 VOUT.n135 6.12575
R385 VOUT.n135 VOUT.t46 0.653833
R386 VOUT.n135 VOUT.t57 0.653833
R387 VOUT.n134 VOUT.n133 6.12575
R388 VOUT.n133 VOUT.t48 0.653833
R389 VOUT.n133 VOUT.t47 0.653833
R390 VOUT.n132 VOUT.n131 6.12575
R391 VOUT.n131 VOUT.t71 0.653833
R392 VOUT.n131 VOUT.t49 0.653833
R393 VOUT.n130 VOUT.n129 6.12575
R394 VOUT.n129 VOUT.t73 0.653833
R395 VOUT.n129 VOUT.t72 0.653833
R396 VOUT.n128 VOUT.n127 6.12575
R397 VOUT.n127 VOUT.t186 0.653833
R398 VOUT.n127 VOUT.t74 0.653833
R399 VOUT.n126 VOUT.n125 6.12575
R400 VOUT.n125 VOUT.t188 0.653833
R401 VOUT.n125 VOUT.t187 0.653833
R402 VOUT.n124 VOUT.n123 6.12575
R403 VOUT.n123 VOUT.t62 0.653833
R404 VOUT.n123 VOUT.t189 0.653833
R405 VOUT.n122 VOUT.n121 6.12575
R406 VOUT.n121 VOUT.t64 0.653833
R407 VOUT.n121 VOUT.t63 0.653833
R408 VOUT.n120 VOUT.n119 6.12575
R409 VOUT.n119 VOUT.t79 0.653833
R410 VOUT.n119 VOUT.t65 0.653833
R411 VOUT.n118 VOUT.n117 6.12575
R412 VOUT.n117 VOUT.t81 0.653833
R413 VOUT.n117 VOUT.t80 0.653833
R414 VOUT.n116 VOUT.n115 6.12575
R415 VOUT.n115 VOUT.t182 0.653833
R416 VOUT.n115 VOUT.t82 0.653833
R417 VOUT.n110 VOUT.n109 6.12575
R418 VOUT.n109 VOUT.t184 0.653833
R419 VOUT.n109 VOUT.t183 0.653833
R420 VOUT.n108 VOUT.n107 6.12575
R421 VOUT.n107 VOUT.t42 0.653833
R422 VOUT.n107 VOUT.t185 0.653833
R423 VOUT.n106 VOUT.n105 6.12575
R424 VOUT.n105 VOUT.t44 0.653833
R425 VOUT.n105 VOUT.t43 0.653833
R426 VOUT.n104 VOUT.n103 1.8005
R427 VOUT.n23 VOUT.n71 6.1745
R428 VOUT.n73 VOUT.n71 0.4001
R429 VOUT.n103 VOUT.n73 0.3461
R430 VOUT.n103 VOUT.n75 0.0545
R431 VOUT.n75 VOUT.n81 0.4001
R432 VOUT.n81 VOUT.n83 0.4001
R433 VOUT.n76 VOUT.n83 0.2993
R434 VOUT.n76 VOUT.n85 0.1013
R435 VOUT.n85 VOUT.n87 0.4001
R436 VOUT.n87 VOUT.n89 0.4001
R437 VOUT.n77 VOUT.n89 0.2525
R438 VOUT.n77 VOUT.n91 0.1481
R439 VOUT.n91 VOUT.n93 0.4001
R440 VOUT.n93 VOUT.n95 0.4001
R441 VOUT.n78 VOUT.n95 0.2057
R442 VOUT.n78 VOUT.n97 0.1949
R443 VOUT.n97 VOUT.n99 0.4001
R444 VOUT.n99 VOUT.n101 0.4001
R445 VOUT.n79 VOUT.n101 0.1589
R446 VOUT.n79 VOUT.n102 6.36695
R447 VOUT.n102 VOUT.t50 0.653833
R448 VOUT.n102 VOUT.t45 0.653833
R449 VOUT.n101 VOUT.n100 6.12575
R450 VOUT.n100 VOUT.t52 0.653833
R451 VOUT.n100 VOUT.t51 0.653833
R452 VOUT.n99 VOUT.n98 6.12575
R453 VOUT.n98 VOUT.t174 0.653833
R454 VOUT.n98 VOUT.t53 0.653833
R455 VOUT.n97 VOUT.n96 6.12575
R456 VOUT.n96 VOUT.t176 0.653833
R457 VOUT.n96 VOUT.t175 0.653833
R458 VOUT.n95 VOUT.n94 6.12575
R459 VOUT.n94 VOUT.t58 0.653833
R460 VOUT.n94 VOUT.t177 0.653833
R461 VOUT.n93 VOUT.n92 6.12575
R462 VOUT.n92 VOUT.t60 0.653833
R463 VOUT.n92 VOUT.t59 0.653833
R464 VOUT.n91 VOUT.n90 6.12575
R465 VOUT.n90 VOUT.t75 0.653833
R466 VOUT.n90 VOUT.t61 0.653833
R467 VOUT.n89 VOUT.n88 6.12575
R468 VOUT.n88 VOUT.t77 0.653833
R469 VOUT.n88 VOUT.t76 0.653833
R470 VOUT.n87 VOUT.n86 6.12575
R471 VOUT.n86 VOUT.t193 0.653833
R472 VOUT.n86 VOUT.t78 0.653833
R473 VOUT.n85 VOUT.n84 6.12575
R474 VOUT.n84 VOUT.t195 0.653833
R475 VOUT.n84 VOUT.t194 0.653833
R476 VOUT.n83 VOUT.n82 6.12575
R477 VOUT.n82 VOUT.t83 0.653833
R478 VOUT.n82 VOUT.t196 0.653833
R479 VOUT.n81 VOUT.n80 6.12575
R480 VOUT.n80 VOUT.t85 0.653833
R481 VOUT.n80 VOUT.t84 0.653833
R482 VOUT.n75 VOUT.n74 6.12575
R483 VOUT.n74 VOUT.t166 0.653833
R484 VOUT.n74 VOUT.t86 0.653833
R485 VOUT.n73 VOUT.n72 6.12575
R486 VOUT.n72 VOUT.t168 0.653833
R487 VOUT.n72 VOUT.t167 0.653833
R488 VOUT.n71 VOUT.n70 6.12575
R489 VOUT.n70 VOUT.t165 0.653833
R490 VOUT.n70 VOUT.t169 0.653833
R491 VOUT.n68 VOUT.n67 6.12575
R492 VOUT.n67 VOUT.t170 0.653833
R493 VOUT.n67 VOUT.t200 0.653833
R494 VOUT.n66 VOUT.n65 6.12575
R495 VOUT.n65 VOUT.t172 0.653833
R496 VOUT.n65 VOUT.t171 0.653833
R497 VOUT.n64 VOUT.n63 6.12575
R498 VOUT.n63 VOUT.t54 0.653833
R499 VOUT.n63 VOUT.t173 0.653833
R500 VOUT.n58 VOUT.n57 6.12575
R501 VOUT.n57 VOUT.t148 0.653833
R502 VOUT.n57 VOUT.t147 0.653833
R503 VOUT.n56 VOUT.n55 6.12575
R504 VOUT.n55 VOUT.t36 0.653833
R505 VOUT.n55 VOUT.t149 0.653833
R506 VOUT.n54 VOUT.n53 6.12575
R507 VOUT.n53 VOUT.t38 0.653833
R508 VOUT.n53 VOUT.t37 0.653833
R509 VOUT.n46 VOUT.n45 6.12575
R510 VOUT.n45 VOUT.t126 0.653833
R511 VOUT.n45 VOUT.t145 0.653833
R512 VOUT.n44 VOUT.n43 6.12575
R513 VOUT.n43 VOUT.t128 0.653833
R514 VOUT.n43 VOUT.t127 0.653833
R515 VOUT.n42 VOUT.n41 6.12575
R516 VOUT.n41 VOUT.t122 0.653833
R517 VOUT.n41 VOUT.t129 0.653833
R518 VOUT.n32 VOUT.n31 6.12575
R519 VOUT.n31 VOUT.t91 0.653833
R520 VOUT.n31 VOUT.t90 0.653833
R521 VOUT.n30 VOUT.n29 6.12575
R522 VOUT.n29 VOUT.t97 0.653833
R523 VOUT.n29 VOUT.t92 0.653833
R524 VOUT.n28 VOUT.n27 6.12575
R525 VOUT.n27 VOUT.t99 0.653833
R526 VOUT.n27 VOUT.t98 0.653833
R527 VOUT.n18 VOUT.n17 6.12575
R528 VOUT.n17 VOUT.t191 0.653833
R529 VOUT.n17 VOUT.t8 0.653833
R530 VOUT.n16 VOUT.n15 6.12575
R531 VOUT.n15 VOUT.t205 0.653833
R532 VOUT.n15 VOUT.t164 0.653833
R533 VOUT.n14 VOUT.n13 6.12575
R534 VOUT.n13 VOUT.t1 0.653833
R535 VOUT.n13 VOUT.t12 0.653833
R536 VOUT.n0 VOUT.n1 5.5877
R537 VOUT.n2 VOUT.n0 0.754045
R538 VOUT.n1 VOUT.t202 34.6185
R539 VOUT.n1 VOUT.t203 17.2397
R540 VOUT.n0 VOUT.t20 24.9919
R541 VIN VIN.n1183 0.0505
R542 VIN.n1183 VIN.n1184 0.0497
R543 VIN.n1184 VIN.n1185 0.0431667
R544 VIN.n1185 VIN.n1186 0.0431667
R545 VIN.n1186 VIN.n1187 0.0431667
R546 VIN.n1188 VIN.n1242 1.8005
R547 VIN.n1189 VIN.n1277 1.8005
R548 VIN.n1190 VIN.n1312 1.8005
R549 VIN.n1191 VIN.n1345 1.8005
R550 VIN.n1192 VIN.n1376 1.8005
R551 VIN.n1193 VIN.n1406 1.8005
R552 VIN.n1192 VIN.n1193 0.214769
R553 VIN.n1191 VIN.n1192 0.214769
R554 VIN.n1190 VIN.n1191 0.214769
R555 VIN.n1189 VIN.n1190 0.214769
R556 VIN.n1188 VIN.n1189 0.214769
R557 VIN.n1187 VIN.n1188 1.12537
R558 VIN.n1193 VIN.n1460 2.01477
R559 VIN.n1308 VIN.n1197 2.01477
R560 VIN.n1342 VIN.n1198 2.01477
R561 VIN.n1374 VIN.n1199 2.01477
R562 VIN.n1405 VIN.n1200 2.01477
R563 VIN.n1433 VIN.n1194 5.8127
R564 VIN.n1197 VIN.n1194 0.3695
R565 VIN.n1197 VIN.n1196 0.0311
R566 VIN.n1196 VIN.n1435 0.4001
R567 VIN.n1435 VIN.n1437 0.4001
R568 VIN.n1198 VIN.n1437 0.3227
R569 VIN.n1198 VIN.n1439 0.0779
R570 VIN.n1439 VIN.n1441 0.4001
R571 VIN.n1441 VIN.n1443 0.4001
R572 VIN.n1199 VIN.n1443 0.2759
R573 VIN.n1199 VIN.n1445 0.1247
R574 VIN.n1445 VIN.n1447 0.4001
R575 VIN.n1447 VIN.n1449 0.4001
R576 VIN.n1200 VIN.n1449 0.2291
R577 VIN.n1200 VIN.n1451 0.1715
R578 VIN.n1451 VIN.n1453 0.4001
R579 VIN.n1453 VIN.n1455 0.4001
R580 VIN.n1460 VIN.n1455 0.1823
R581 VIN.n1460 VIN.n1457 0.2183
R582 VIN.n1457 VIN.n1459 0.4001
R583 VIN.n1459 VIN.t17 7.02216
R584 VIN.n1459 VIN.n1458 5.96923
R585 VIN.n1458 VIN.t9 0.653833
R586 VIN.n1458 VIN.t247 0.653833
R587 VIN.n1457 VIN.n1456 5.96923
R588 VIN.n1456 VIN.t23 0.653833
R589 VIN.n1456 VIN.t104 0.653833
R590 VIN.n1455 VIN.n1454 5.96923
R591 VIN.n1454 VIN.t73 0.653833
R592 VIN.n1454 VIN.t74 0.653833
R593 VIN.n1453 VIN.n1452 5.96923
R594 VIN.n1452 VIN.t21 0.653833
R595 VIN.n1452 VIN.t1 0.653833
R596 VIN.n1451 VIN.n1450 5.96923
R597 VIN.n1450 VIN.t170 0.653833
R598 VIN.n1450 VIN.t35 0.653833
R599 VIN.n1449 VIN.n1448 5.96923
R600 VIN.n1448 VIN.t12 0.653833
R601 VIN.n1448 VIN.t37 0.653833
R602 VIN.n1447 VIN.n1446 5.96923
R603 VIN.n1446 VIN.t47 0.653833
R604 VIN.n1446 VIN.t58 0.653833
R605 VIN.n1445 VIN.n1444 5.96923
R606 VIN.n1444 VIN.t42 0.653833
R607 VIN.n1444 VIN.t158 0.653833
R608 VIN.n1443 VIN.n1442 5.96923
R609 VIN.n1442 VIN.t164 0.653833
R610 VIN.n1442 VIN.t5 0.653833
R611 VIN.n1441 VIN.n1440 5.96923
R612 VIN.n1440 VIN.t44 0.653833
R613 VIN.n1440 VIN.t260 0.653833
R614 VIN.n1439 VIN.n1438 5.96923
R615 VIN.n1438 VIN.t165 0.653833
R616 VIN.n1438 VIN.t27 0.653833
R617 VIN.n1437 VIN.n1436 5.96923
R618 VIN.n1436 VIN.t19 0.653833
R619 VIN.n1436 VIN.t31 0.653833
R620 VIN.n1435 VIN.n1434 5.96923
R621 VIN.n1434 VIN.t221 0.653833
R622 VIN.n1434 VIN.t248 0.653833
R623 VIN.n1433 VIN.n1204 1.1147
R624 VIN.n1204 VIN.n1203 1.1147
R625 VIN.n1203 VIN.n1202 1.1147
R626 VIN.n1202 VIN.n1201 1.1147
R627 VIN.n1308 VIN.n1208 1.8005
R628 VIN.n1342 VIN.n1209 1.8005
R629 VIN.n1374 VIN.n1210 1.8005
R630 VIN.n1205 VIN.n1433 4.6985
R631 VIN.n1208 VIN.n1205 0.3695
R632 VIN.n1208 VIN.n1207 0.0311
R633 VIN.n1207 VIN.n1408 0.4001
R634 VIN.n1408 VIN.n1410 0.4001
R635 VIN.n1209 VIN.n1410 0.3227
R636 VIN.n1209 VIN.n1412 0.0779
R637 VIN.n1412 VIN.n1414 0.4001
R638 VIN.n1414 VIN.n1416 0.4001
R639 VIN.n1210 VIN.n1416 0.2759
R640 VIN.n1210 VIN.n1418 0.1247
R641 VIN.n1418 VIN.n1420 0.4001
R642 VIN.n1420 VIN.n1422 0.4001
R643 VIN.n1211 VIN.n1422 0.2291
R644 VIN.n1211 VIN.n1424 0.1715
R645 VIN.n1424 VIN.n1426 0.4001
R646 VIN.n1426 VIN.n1428 0.4001
R647 VIN.n1406 VIN.n1428 0.1823
R648 VIN.n1406 VIN.n1430 0.2183
R649 VIN.n1430 VIN.n1432 0.4001
R650 VIN.n1432 VIN.t220 7.02216
R651 VIN.n1432 VIN.n1431 5.96923
R652 VIN.n1431 VIN.t38 0.653833
R653 VIN.n1431 VIN.t49 0.653833
R654 VIN.n1430 VIN.n1429 5.96923
R655 VIN.n1429 VIN.t159 0.653833
R656 VIN.n1429 VIN.t66 0.653833
R657 VIN.n1428 VIN.n1427 5.96923
R658 VIN.n1427 VIN.t14 0.653833
R659 VIN.n1427 VIN.t40 0.653833
R660 VIN.n1426 VIN.n1425 5.96923
R661 VIN.n1425 VIN.t211 0.653833
R662 VIN.n1425 VIN.t67 0.653833
R663 VIN.n1424 VIN.n1423 5.96923
R664 VIN.n1423 VIN.t7 0.653833
R665 VIN.n1423 VIN.t59 0.653833
R666 VIN.n1422 VIN.n1421 5.96923
R667 VIN.n1421 VIN.t251 0.653833
R668 VIN.n1421 VIN.t56 0.653833
R669 VIN.n1420 VIN.n1419 5.96923
R670 VIN.n1419 VIN.t139 0.653833
R671 VIN.n1419 VIN.t138 0.653833
R672 VIN.n1418 VIN.n1417 5.96923
R673 VIN.n1417 VIN.t277 0.653833
R674 VIN.n1417 VIN.t276 0.653833
R675 VIN.n1416 VIN.n1415 5.96923
R676 VIN.n1415 VIN.t279 0.653833
R677 VIN.n1415 VIN.t278 0.653833
R678 VIN.n1414 VIN.n1413 5.96923
R679 VIN.n1413 VIN.t236 0.653833
R680 VIN.n1413 VIN.t235 0.653833
R681 VIN.n1412 VIN.n1411 5.96923
R682 VIN.n1411 VIN.t238 0.653833
R683 VIN.n1411 VIN.t237 0.653833
R684 VIN.n1410 VIN.n1409 5.96923
R685 VIN.n1409 VIN.t141 0.653833
R686 VIN.n1409 VIN.t140 0.653833
R687 VIN.n1408 VIN.n1407 5.96923
R688 VIN.n1407 VIN.t145 0.653833
R689 VIN.n1407 VIN.t143 0.653833
R690 VIN.n1405 VIN.n1211 1.8005
R691 VIN.n1212 VIN.n1241 1.8005
R692 VIN.n1213 VIN.n1276 1.8005
R693 VIN.n1214 VIN.n1311 1.8005
R694 VIN.n1215 VIN.n1344 1.8005
R695 VIN.n1404 VIN.n1405 0.214769
R696 VIN.n1215 VIN.n1404 0.214769
R697 VIN.n1214 VIN.n1215 0.214769
R698 VIN.n1213 VIN.n1214 0.214769
R699 VIN.n1212 VIN.n1213 0.214769
R700 VIN.n1187 VIN.n1212 1.0827
R701 VIN.n1404 VIN.n1403 1.8005
R702 VIN.n1307 VIN.n1219 1.8005
R703 VIN.n1341 VIN.n1220 1.8005
R704 VIN.n1216 VIN.n1204 4.6985
R705 VIN.n1219 VIN.n1216 0.3695
R706 VIN.n1219 VIN.n1218 0.0311
R707 VIN.n1218 VIN.n1378 0.4001
R708 VIN.n1378 VIN.n1380 0.4001
R709 VIN.n1220 VIN.n1380 0.3227
R710 VIN.n1220 VIN.n1382 0.0779
R711 VIN.n1382 VIN.n1384 0.4001
R712 VIN.n1384 VIN.n1386 0.4001
R713 VIN.n1221 VIN.n1386 0.2759
R714 VIN.n1221 VIN.n1388 0.1247
R715 VIN.n1388 VIN.n1390 0.4001
R716 VIN.n1390 VIN.n1392 0.4001
R717 VIN.n1403 VIN.n1392 0.2291
R718 VIN.n1403 VIN.n1394 0.1715
R719 VIN.n1394 VIN.n1396 0.4001
R720 VIN.n1396 VIN.n1398 0.4001
R721 VIN.n1376 VIN.n1398 0.1823
R722 VIN.n1376 VIN.n1400 0.2183
R723 VIN.n1400 VIN.n1402 0.4001
R724 VIN.n1402 VIN.t153 7.02216
R725 VIN.n1402 VIN.n1401 5.96923
R726 VIN.n1401 VIN.t147 0.653833
R727 VIN.n1401 VIN.t146 0.653833
R728 VIN.n1400 VIN.n1399 5.96923
R729 VIN.n1399 VIN.t149 0.653833
R730 VIN.n1399 VIN.t148 0.653833
R731 VIN.n1398 VIN.n1397 5.96923
R732 VIN.n1397 VIN.t155 0.653833
R733 VIN.n1397 VIN.t154 0.653833
R734 VIN.n1396 VIN.n1395 5.96923
R735 VIN.n1395 VIN.t157 0.653833
R736 VIN.n1395 VIN.t156 0.653833
R737 VIN.n1394 VIN.n1393 5.96923
R738 VIN.n1393 VIN.t217 0.653833
R739 VIN.n1393 VIN.t216 0.653833
R740 VIN.n1392 VIN.n1391 5.96923
R741 VIN.n1391 VIN.t219 0.653833
R742 VIN.n1391 VIN.t218 0.653833
R743 VIN.n1390 VIN.n1389 5.96923
R744 VIN.n1389 VIN.t161 0.653833
R745 VIN.n1389 VIN.t160 0.653833
R746 VIN.n1388 VIN.n1387 5.96923
R747 VIN.n1387 VIN.t163 0.653833
R748 VIN.n1387 VIN.t162 0.653833
R749 VIN.n1386 VIN.n1385 5.96923
R750 VIN.n1385 VIN.t192 0.653833
R751 VIN.n1385 VIN.t191 0.653833
R752 VIN.n1384 VIN.n1383 5.96923
R753 VIN.n1383 VIN.t194 0.653833
R754 VIN.n1383 VIN.t193 0.653833
R755 VIN.n1382 VIN.n1381 5.96923
R756 VIN.n1381 VIN.t200 0.653833
R757 VIN.n1381 VIN.t199 0.653833
R758 VIN.n1380 VIN.n1379 5.96923
R759 VIN.n1379 VIN.t202 0.653833
R760 VIN.n1379 VIN.t201 0.653833
R761 VIN.n1378 VIN.n1377 5.96923
R762 VIN.n1377 VIN.t184 0.653833
R763 VIN.n1377 VIN.t183 0.653833
R764 VIN.n1375 VIN.n1221 1.8005
R765 VIN.n1222 VIN.n1240 1.8005
R766 VIN.n1223 VIN.n1275 1.8005
R767 VIN.n1224 VIN.n1310 1.8005
R768 VIN.n1375 VIN.n1374 0.214769
R769 VIN.n1373 VIN.n1375 0.214769
R770 VIN.n1224 VIN.n1373 0.214769
R771 VIN.n1223 VIN.n1224 0.214769
R772 VIN.n1222 VIN.n1223 0.214769
R773 VIN.n1186 VIN.n1222 1.0827
R774 VIN.n1373 VIN.n1372 1.8005
R775 VIN.n1306 VIN.n1228 1.8005
R776 VIN.n1225 VIN.n1203 4.6985
R777 VIN.n1228 VIN.n1225 0.3695
R778 VIN.n1228 VIN.n1227 0.0311
R779 VIN.n1227 VIN.n1347 0.4001
R780 VIN.n1347 VIN.n1349 0.4001
R781 VIN.n1229 VIN.n1349 0.3227
R782 VIN.n1229 VIN.n1351 0.0779
R783 VIN.n1351 VIN.n1353 0.4001
R784 VIN.n1353 VIN.n1355 0.4001
R785 VIN.n1372 VIN.n1355 0.2759
R786 VIN.n1372 VIN.n1357 0.1247
R787 VIN.n1357 VIN.n1359 0.4001
R788 VIN.n1359 VIN.n1361 0.4001
R789 VIN.n1344 VIN.n1361 0.2291
R790 VIN.n1344 VIN.n1363 0.1715
R791 VIN.n1363 VIN.n1365 0.4001
R792 VIN.n1365 VIN.n1367 0.4001
R793 VIN.n1345 VIN.n1367 0.1823
R794 VIN.n1345 VIN.n1369 0.2183
R795 VIN.n1369 VIN.n1371 0.4001
R796 VIN.n1371 VIN.t180 7.02216
R797 VIN.n1371 VIN.n1370 5.96923
R798 VIN.n1370 VIN.t182 0.653833
R799 VIN.n1370 VIN.t181 0.653833
R800 VIN.n1369 VIN.n1368 5.96923
R801 VIN.n1368 VIN.t188 0.653833
R802 VIN.n1368 VIN.t187 0.653833
R803 VIN.n1367 VIN.n1366 5.96923
R804 VIN.n1366 VIN.t190 0.653833
R805 VIN.n1366 VIN.t189 0.653833
R806 VIN.n1365 VIN.n1364 5.96923
R807 VIN.n1364 VIN.t213 0.653833
R808 VIN.n1364 VIN.t212 0.653833
R809 VIN.n1363 VIN.n1362 5.96923
R810 VIN.n1362 VIN.t215 0.653833
R811 VIN.n1362 VIN.t214 0.653833
R812 VIN.n1361 VIN.n1360 5.96923
R813 VIN.n1360 VIN.t176 0.653833
R814 VIN.n1360 VIN.t175 0.653833
R815 VIN.n1359 VIN.n1358 5.96923
R816 VIN.n1358 VIN.t178 0.653833
R817 VIN.n1358 VIN.t177 0.653833
R818 VIN.n1357 VIN.n1356 5.96923
R819 VIN.n1356 VIN.t208 0.653833
R820 VIN.n1356 VIN.t207 0.653833
R821 VIN.n1355 VIN.n1354 5.96923
R822 VIN.n1354 VIN.t210 0.653833
R823 VIN.n1354 VIN.t209 0.653833
R824 VIN.n1353 VIN.n1352 5.96923
R825 VIN.n1352 VIN.t196 0.653833
R826 VIN.n1352 VIN.t195 0.653833
R827 VIN.n1351 VIN.n1350 5.96923
R828 VIN.n1350 VIN.t198 0.653833
R829 VIN.n1350 VIN.t197 0.653833
R830 VIN.n1349 VIN.n1348 5.96923
R831 VIN.n1348 VIN.t204 0.653833
R832 VIN.n1348 VIN.t203 0.653833
R833 VIN.n1347 VIN.n1346 5.96923
R834 VIN.n1346 VIN.t206 0.653833
R835 VIN.n1346 VIN.t205 0.653833
R836 VIN.n1343 VIN.n1229 1.8005
R837 VIN.n1230 VIN.n1239 1.8005
R838 VIN.n1231 VIN.n1274 1.8005
R839 VIN.n1341 VIN.n1342 0.214769
R840 VIN.n1343 VIN.n1341 0.214769
R841 VIN.n1340 VIN.n1343 0.214769
R842 VIN.n1231 VIN.n1340 0.214769
R843 VIN.n1230 VIN.n1231 0.214769
R844 VIN.n1185 VIN.n1230 1.0827
R845 VIN.n1340 VIN.n1339 1.8005
R846 VIN.n1232 VIN.n1202 4.6985
R847 VIN.n1235 VIN.n1232 0.3695
R848 VIN.n1235 VIN.n1234 0.0311
R849 VIN.n1234 VIN.n1314 0.4001
R850 VIN.n1314 VIN.n1316 0.4001
R851 VIN.n1339 VIN.n1316 0.3227
R852 VIN.n1339 VIN.n1318 0.0779
R853 VIN.n1318 VIN.n1320 0.4001
R854 VIN.n1320 VIN.n1322 0.4001
R855 VIN.n1310 VIN.n1322 0.2759
R856 VIN.n1310 VIN.n1324 0.1247
R857 VIN.n1324 VIN.n1326 0.4001
R858 VIN.n1326 VIN.n1328 0.4001
R859 VIN.n1311 VIN.n1328 0.2291
R860 VIN.n1311 VIN.n1330 0.1715
R861 VIN.n1330 VIN.n1332 0.4001
R862 VIN.n1332 VIN.n1334 0.4001
R863 VIN.n1312 VIN.n1334 0.1823
R864 VIN.n1312 VIN.n1336 0.2183
R865 VIN.n1336 VIN.n1338 0.4001
R866 VIN.n1338 VIN.t72 7.02216
R867 VIN.n1338 VIN.n1337 5.96923
R868 VIN.n1337 VIN.t100 0.653833
R869 VIN.n1337 VIN.t99 0.653833
R870 VIN.n1336 VIN.n1335 5.96923
R871 VIN.n1335 VIN.t102 0.653833
R872 VIN.n1335 VIN.t101 0.653833
R873 VIN.n1334 VIN.n1333 5.96923
R874 VIN.n1333 VIN.t167 0.653833
R875 VIN.n1333 VIN.t166 0.653833
R876 VIN.n1332 VIN.n1331 5.96923
R877 VIN.n1331 VIN.t169 0.653833
R878 VIN.n1331 VIN.t168 0.653833
R879 VIN.n1330 VIN.n1329 5.96923
R880 VIN.n1329 VIN.t271 0.653833
R881 VIN.n1329 VIN.t270 0.653833
R882 VIN.n1328 VIN.n1327 5.96923
R883 VIN.n1327 VIN.t273 0.653833
R884 VIN.n1327 VIN.t272 0.653833
R885 VIN.n1326 VIN.n1325 5.96923
R886 VIN.n1325 VIN.t61 0.653833
R887 VIN.n1325 VIN.t60 0.653833
R888 VIN.n1324 VIN.n1323 5.96923
R889 VIN.n1323 VIN.t64 0.653833
R890 VIN.n1323 VIN.t63 0.653833
R891 VIN.n1322 VIN.n1321 5.96923
R892 VIN.n1321 VIN.t52 0.653833
R893 VIN.n1321 VIN.t50 0.653833
R894 VIN.n1320 VIN.n1319 5.96923
R895 VIN.n1319 VIN.t55 0.653833
R896 VIN.n1319 VIN.t54 0.653833
R897 VIN.n1318 VIN.n1317 5.96923
R898 VIN.n1317 VIN.t257 0.653833
R899 VIN.n1317 VIN.t256 0.653833
R900 VIN.n1316 VIN.n1315 5.96923
R901 VIN.n1315 VIN.t259 0.653833
R902 VIN.n1315 VIN.t258 0.653833
R903 VIN.n1314 VIN.n1313 5.96923
R904 VIN.n1313 VIN.t228 0.653833
R905 VIN.n1313 VIN.t227 0.653833
R906 VIN.n1309 VIN.n1235 1.8005
R907 VIN.n1307 VIN.n1308 0.214769
R908 VIN.n1306 VIN.n1307 0.214769
R909 VIN.n1309 VIN.n1306 0.214769
R910 VIN.n1305 VIN.n1309 0.214769
R911 VIN.n1270 VIN.n1305 0.214769
R912 VIN.n1184 VIN.n1270 1.0827
R913 VIN.n1305 VIN.n1304 1.8005
R914 VIN.n1271 VIN.n1201 4.6985
R915 VIN.n1304 VIN.n1271 0.3695
R916 VIN.n1304 VIN.n1273 0.0311
R917 VIN.n1273 VIN.n1279 0.4001
R918 VIN.n1279 VIN.n1281 0.4001
R919 VIN.n1274 VIN.n1281 0.3227
R920 VIN.n1274 VIN.n1283 0.0779
R921 VIN.n1283 VIN.n1285 0.4001
R922 VIN.n1285 VIN.n1287 0.4001
R923 VIN.n1275 VIN.n1287 0.2759
R924 VIN.n1275 VIN.n1289 0.1247
R925 VIN.n1289 VIN.n1291 0.4001
R926 VIN.n1291 VIN.n1293 0.4001
R927 VIN.n1276 VIN.n1293 0.2291
R928 VIN.n1276 VIN.n1295 0.1715
R929 VIN.n1295 VIN.n1297 0.4001
R930 VIN.n1297 VIN.n1299 0.4001
R931 VIN.n1277 VIN.n1299 0.1823
R932 VIN.n1277 VIN.n1301 0.2183
R933 VIN.n1301 VIN.n1303 0.4001
R934 VIN.n1303 VIN.t88 7.02216
R935 VIN.n1303 VIN.n1302 5.96923
R936 VIN.n1302 VIN.t90 0.653833
R937 VIN.n1302 VIN.t89 0.653833
R938 VIN.n1301 VIN.n1300 5.96923
R939 VIN.n1300 VIN.t80 0.653833
R940 VIN.n1300 VIN.t79 0.653833
R941 VIN.n1299 VIN.n1298 5.96923
R942 VIN.n1298 VIN.t82 0.653833
R943 VIN.n1298 VIN.t81 0.653833
R944 VIN.n1297 VIN.n1296 5.96923
R945 VIN.n1296 VIN.t122 0.653833
R946 VIN.n1296 VIN.t121 0.653833
R947 VIN.n1295 VIN.n1294 5.96923
R948 VIN.n1294 VIN.t124 0.653833
R949 VIN.n1294 VIN.t123 0.653833
R950 VIN.n1293 VIN.n1292 5.96923
R951 VIN.n1292 VIN.t244 0.653833
R952 VIN.n1292 VIN.t243 0.653833
R953 VIN.n1291 VIN.n1290 5.96923
R954 VIN.n1290 VIN.t246 0.653833
R955 VIN.n1290 VIN.t245 0.653833
R956 VIN.n1289 VIN.n1288 5.96923
R957 VIN.n1288 VIN.t96 0.653833
R958 VIN.n1288 VIN.t95 0.653833
R959 VIN.n1287 VIN.n1286 5.96923
R960 VIN.n1286 VIN.t98 0.653833
R961 VIN.n1286 VIN.t97 0.653833
R962 VIN.n1285 VIN.n1284 5.96923
R963 VIN.n1284 VIN.t130 0.653833
R964 VIN.n1284 VIN.t129 0.653833
R965 VIN.n1283 VIN.n1282 5.96923
R966 VIN.n1282 VIN.t133 0.653833
R967 VIN.n1282 VIN.t131 0.653833
R968 VIN.n1281 VIN.n1280 5.96923
R969 VIN.n1280 VIN.t240 0.653833
R970 VIN.n1280 VIN.t239 0.653833
R971 VIN.n1279 VIN.n1278 5.96923
R972 VIN.n1278 VIN.t242 0.653833
R973 VIN.n1278 VIN.t241 0.653833
R974 VIN.n1273 VIN.n1272 5.96923
R975 VIN.n1272 VIN.t76 0.653833
R976 VIN.n1272 VIN.t75 0.653833
R977 VIN.n1271 VIN.t77 6.62256
R978 VIN.n1270 VIN.n1269 1.8005
R979 VIN.n1201 VIN.n1236 5.8127
R980 VIN.n1269 VIN.n1236 0.3695
R981 VIN.n1269 VIN.n1238 0.0311
R982 VIN.n1238 VIN.n1244 0.4001
R983 VIN.n1244 VIN.n1246 0.4001
R984 VIN.n1239 VIN.n1246 0.3227
R985 VIN.n1239 VIN.n1248 0.0779
R986 VIN.n1248 VIN.n1250 0.4001
R987 VIN.n1250 VIN.n1252 0.4001
R988 VIN.n1240 VIN.n1252 0.2759
R989 VIN.n1240 VIN.n1254 0.1247
R990 VIN.n1254 VIN.n1256 0.4001
R991 VIN.n1256 VIN.n1258 0.4001
R992 VIN.n1241 VIN.n1258 0.2291
R993 VIN.n1241 VIN.n1260 0.1715
R994 VIN.n1260 VIN.n1262 0.4001
R995 VIN.n1262 VIN.n1264 0.4001
R996 VIN.n1242 VIN.n1264 0.1823
R997 VIN.n1242 VIN.n1266 0.2183
R998 VIN.n1266 VIN.n1268 0.4001
R999 VIN.n1268 VIN.t78 7.02216
R1000 VIN.n1268 VIN.n1267 5.96923
R1001 VIN.n1267 VIN.t84 0.653833
R1002 VIN.n1267 VIN.t83 0.653833
R1003 VIN.n1266 VIN.n1265 5.96923
R1004 VIN.n1265 VIN.t86 0.653833
R1005 VIN.n1265 VIN.t85 0.653833
R1006 VIN.n1264 VIN.n1263 5.96923
R1007 VIN.n1263 VIN.t232 0.653833
R1008 VIN.n1263 VIN.t231 0.653833
R1009 VIN.n1262 VIN.n1261 5.96923
R1010 VIN.n1261 VIN.t234 0.653833
R1011 VIN.n1261 VIN.t233 0.653833
R1012 VIN.n1260 VIN.n1259 5.96923
R1013 VIN.n1259 VIN.t92 0.653833
R1014 VIN.n1259 VIN.t91 0.653833
R1015 VIN.n1258 VIN.n1257 5.96923
R1016 VIN.n1257 VIN.t94 0.653833
R1017 VIN.n1257 VIN.t93 0.653833
R1018 VIN.n1256 VIN.n1255 5.96923
R1019 VIN.n1255 VIN.t126 0.653833
R1020 VIN.n1255 VIN.t125 0.653833
R1021 VIN.n1254 VIN.n1253 5.96923
R1022 VIN.n1253 VIN.t128 0.653833
R1023 VIN.n1253 VIN.t127 0.653833
R1024 VIN.n1252 VIN.n1251 5.96923
R1025 VIN.n1251 VIN.t253 0.653833
R1026 VIN.n1251 VIN.t252 0.653833
R1027 VIN.n1250 VIN.n1249 5.96923
R1028 VIN.n1249 VIN.t255 0.653833
R1029 VIN.n1249 VIN.t254 0.653833
R1030 VIN.n1248 VIN.n1247 5.96923
R1031 VIN.n1247 VIN.t135 0.653833
R1032 VIN.n1247 VIN.t134 0.653833
R1033 VIN.n1246 VIN.n1245 5.96923
R1034 VIN.n1245 VIN.t137 0.653833
R1035 VIN.n1245 VIN.t136 0.653833
R1036 VIN.n1244 VIN.n1243 5.96923
R1037 VIN.n1243 VIN.t224 0.653833
R1038 VIN.n1243 VIN.t223 0.653833
R1039 VIN.n1238 VIN.n1237 5.96923
R1040 VIN.n1237 VIN.t226 0.653833
R1041 VIN.n1237 VIN.t225 0.653833
R1042 VIN.n1236 VIN.t222 6.62256
R1043 VIN.n1234 VIN.n1233 5.96923
R1044 VIN.n1233 VIN.t230 0.653833
R1045 VIN.n1233 VIN.t229 0.653833
R1046 VIN.n1232 VIN.t87 6.62256
R1047 VIN.n1227 VIN.n1226 5.96923
R1048 VIN.n1226 VIN.t70 0.653833
R1049 VIN.n1226 VIN.t69 0.653833
R1050 VIN.n1225 VIN.t71 6.62256
R1051 VIN.n1218 VIN.n1217 5.96923
R1052 VIN.n1217 VIN.t186 0.653833
R1053 VIN.n1217 VIN.t185 0.653833
R1054 VIN.n1216 VIN.t179 6.62256
R1055 VIN.n1207 VIN.n1206 5.96923
R1056 VIN.n1206 VIN.t151 0.653833
R1057 VIN.n1206 VIN.t150 0.653833
R1058 VIN.n1205 VIN.t152 6.62256
R1059 VIN.n1196 VIN.n1195 5.96923
R1060 VIN.n1195 VIN.t29 0.653833
R1061 VIN.n1195 VIN.t267 0.653833
R1062 VIN.n1194 VIN.t3 6.62256
R1063 VIN.n1183 VIN.n331 7.71285
R1064 VIN.n331 VIN.n1182 3.7742
R1065 VIN.n695 VIN.n694 9.57614
R1066 VIN.n696 VIN.n695 0.82715
R1067 VIN.n697 VIN.n696 0.8771
R1068 VIN.n719 VIN.n697 1.895
R1069 VIN.n755 VIN.n719 1.7924
R1070 VIN.n777 VIN.n755 2.921
R1071 VIN.n1182 VIN.n777 0.6764
R1072 VIN.n1182 VIN.n1181 13.0569
R1073 VIN.n918 VIN.n917 4.5005
R1074 VIN.n1099 VIN.n919 4.5005
R1075 VIN.n920 VIN.n921 4.5005
R1076 VIN.n922 VIN.n923 4.5005
R1077 VIN.n925 VIN.n924 4.5005
R1078 VIN.n926 VIN.n927 4.5005
R1079 VIN.n928 VIN.n929 4.5005
R1080 VIN.n930 VIN.n931 4.5005
R1081 VIN.n933 VIN.n932 4.5005
R1082 VIN.n934 VIN.n935 4.5005
R1083 VIN.n936 VIN.n937 4.5005
R1084 VIN.n938 VIN.n939 4.5005
R1085 VIN.n940 VIN.n941 4.5005
R1086 VIN.n942 VIN.n943 4.5005
R1087 VIN.n944 VIN.n945 4.5005
R1088 VIN.n946 VIN.n947 4.5005
R1089 VIN.n948 VIN.n949 4.5005
R1090 VIN.n950 VIN.n951 4.5005
R1091 VIN.n952 VIN.n953 4.5005
R1092 VIN.n954 VIN.n955 4.5005
R1093 VIN.n956 VIN.n957 4.5005
R1094 VIN.n959 VIN.n958 4.5005
R1095 VIN.n961 VIN.n960 4.5005
R1096 VIN.n963 VIN.n962 4.5005
R1097 VIN.n964 VIN.n965 4.5005
R1098 VIN.n966 VIN.n967 4.5005
R1099 VIN.n968 VIN.n969 4.5005
R1100 VIN.n970 VIN.n971 4.5005
R1101 VIN.n972 VIN.n973 4.5005
R1102 VIN.n974 VIN.n975 4.5005
R1103 VIN.n977 VIN.n976 4.5005
R1104 VIN.n979 VIN.n978 4.5005
R1105 VIN.n981 VIN.n980 4.5005
R1106 VIN.n983 VIN.n982 4.5005
R1107 VIN.n985 VIN.n984 4.5005
R1108 VIN.n987 VIN.n986 4.5005
R1109 VIN.n921 VIN.n919 0.1445
R1110 VIN.n923 VIN.n921 0.1445
R1111 VIN.n925 VIN.n923 0.1445
R1112 VIN.n927 VIN.n925 0.1445
R1113 VIN.n929 VIN.n927 0.1445
R1114 VIN.n931 VIN.n929 0.1445
R1115 VIN.n933 VIN.n931 0.1445
R1116 VIN.n935 VIN.n933 0.1445
R1117 VIN.n937 VIN.n935 0.1445
R1118 VIN.n939 VIN.n937 0.1445
R1119 VIN.n941 VIN.n939 0.1445
R1120 VIN.n943 VIN.n941 0.1445
R1121 VIN.n945 VIN.n943 0.1445
R1122 VIN.n947 VIN.n945 0.1445
R1123 VIN.n949 VIN.n947 0.1445
R1124 VIN.n951 VIN.n949 0.1445
R1125 VIN.n953 VIN.n951 0.1445
R1126 VIN.n955 VIN.n953 0.1445
R1127 VIN.n957 VIN.n955 0.1445
R1128 VIN.n959 VIN.n957 0.1445
R1129 VIN.n961 VIN.n959 0.1445
R1130 VIN.n963 VIN.n961 0.1445
R1131 VIN.n965 VIN.n963 0.1445
R1132 VIN.n967 VIN.n965 0.1445
R1133 VIN.n969 VIN.n967 0.1445
R1134 VIN.n971 VIN.n969 0.1445
R1135 VIN.n973 VIN.n971 0.1445
R1136 VIN.n975 VIN.n973 0.1445
R1137 VIN.n977 VIN.n975 0.1445
R1138 VIN.n979 VIN.n977 0.1445
R1139 VIN.n981 VIN.n979 0.1445
R1140 VIN.n983 VIN.n981 0.1445
R1141 VIN.n985 VIN.n983 0.1445
R1142 VIN.n987 VIN.n985 0.1445
R1143 VIN.n918 VIN.n987 0.1445
R1144 VIN.n1181 VIN.n918 0.1751
R1145 VIN.n1181 VIN.n1178 4.9793
R1146 VIN.n1180 VIN.n1179 0.348761
R1147 VIN.n1178 VIN.n1180 0.229413
R1148 VIN.n1179 VIN.t119 1.85463
R1149 VIN.n1180 VIN.t120 1.50636
R1150 VIN.n1179 VIN.t117 21.2289
R1151 VIN.n990 VIN.n989 0.263
R1152 VIN.n1178 VIN.n990 0.717565
R1153 VIN.n990 VIN.n992 5.96096
R1154 VIN.n992 VIN.n991 4.5005
R1155 VIN.n1172 VIN.n993 4.5005
R1156 VIN.n994 VIN.n995 4.5005
R1157 VIN.n996 VIN.n997 4.5005
R1158 VIN.n998 VIN.n999 4.5005
R1159 VIN.n1000 VIN.n1001 4.5005
R1160 VIN.n1003 VIN.n1002 4.5005
R1161 VIN.n1005 VIN.n1004 4.5005
R1162 VIN.n1007 VIN.n1006 4.5005
R1163 VIN.n1009 VIN.n1008 4.5005
R1164 VIN.n1011 VIN.n1010 4.5005
R1165 VIN.n1013 VIN.n1012 4.5005
R1166 VIN.n1015 VIN.n1014 4.5005
R1167 VIN.n1017 VIN.n1016 4.5005
R1168 VIN.n1019 VIN.n1018 4.5005
R1169 VIN.n1021 VIN.n1020 4.5005
R1170 VIN.n1023 VIN.n1022 4.5005
R1171 VIN.n1025 VIN.n1024 4.5005
R1172 VIN.n1027 VIN.n1026 4.5005
R1173 VIN.n1029 VIN.n1028 4.5005
R1174 VIN.n1031 VIN.n1030 4.5005
R1175 VIN.n1033 VIN.n1032 4.5005
R1176 VIN.n1035 VIN.n1034 4.5005
R1177 VIN.n1036 VIN.n1037 4.5005
R1178 VIN.n1039 VIN.n1038 4.5005
R1179 VIN.n1041 VIN.n1040 4.5005
R1180 VIN.n1043 VIN.n1042 4.5005
R1181 VIN.n1045 VIN.n1044 4.5005
R1182 VIN.n1047 VIN.n1046 4.5005
R1183 VIN.n1049 VIN.n1048 4.5005
R1184 VIN.n1051 VIN.n1050 4.5005
R1185 VIN.n1053 VIN.n1052 4.5005
R1186 VIN.n1054 VIN.n1055 4.5005
R1187 VIN.n1057 VIN.n1056 4.5005
R1188 VIN.n1058 VIN.n1059 4.5005
R1189 VIN.n1060 VIN.n1061 4.5005
R1190 VIN.n995 VIN.n993 0.1445
R1191 VIN.n997 VIN.n995 0.1445
R1192 VIN.n999 VIN.n997 0.1445
R1193 VIN.n1001 VIN.n999 0.1445
R1194 VIN.n1003 VIN.n1001 0.1445
R1195 VIN.n1005 VIN.n1003 0.1445
R1196 VIN.n1007 VIN.n1005 0.1445
R1197 VIN.n1009 VIN.n1007 0.1445
R1198 VIN.n1011 VIN.n1009 0.1445
R1199 VIN.n1013 VIN.n1011 0.1445
R1200 VIN.n1015 VIN.n1013 0.1445
R1201 VIN.n1017 VIN.n1015 0.1445
R1202 VIN.n1019 VIN.n1017 0.1445
R1203 VIN.n1021 VIN.n1019 0.1445
R1204 VIN.n1023 VIN.n1021 0.1445
R1205 VIN.n1025 VIN.n1023 0.1445
R1206 VIN.n1027 VIN.n1025 0.1445
R1207 VIN.n1029 VIN.n1027 0.1445
R1208 VIN.n1031 VIN.n1029 0.1445
R1209 VIN.n1033 VIN.n1031 0.1445
R1210 VIN.n1035 VIN.n1033 0.1445
R1211 VIN.n1037 VIN.n1035 0.1445
R1212 VIN.n1039 VIN.n1037 0.1445
R1213 VIN.n1041 VIN.n1039 0.1445
R1214 VIN.n1043 VIN.n1041 0.1445
R1215 VIN.n1045 VIN.n1043 0.1445
R1216 VIN.n1047 VIN.n1045 0.1445
R1217 VIN.n1049 VIN.n1047 0.1445
R1218 VIN.n1051 VIN.n1049 0.1445
R1219 VIN.n1053 VIN.n1051 0.1445
R1220 VIN.n1055 VIN.n1053 0.1445
R1221 VIN.n1057 VIN.n1055 0.1445
R1222 VIN.n1059 VIN.n1057 0.1445
R1223 VIN.n1061 VIN.n1059 0.1445
R1224 VIN.n992 VIN.n1061 0.1445
R1225 VIN.n1174 VIN.n1173 0.263
R1226 VIN.n1175 VIN.n1174 0.717565
R1227 VIN.n1174 VIN.n993 5.96096
R1228 VIN.n1175 VIN.n1177 0.229413
R1229 VIN.n1177 VIN.n1176 0.348761
R1230 VIN.n1177 VIN.t115 1.50636
R1231 VIN.n1176 VIN.t116 1.85463
R1232 VIN.n1176 VIN.t113 21.2289
R1233 VIN.n919 VIN.n1175 5.1539
R1234 VIN.n1063 VIN.n988 3.39462
R1235 VIN.n917 VIN.n1063 6.3005
R1236 VIN.n1064 VIN.n1102 6.3005
R1237 VIN.n986 VIN.n1064 6.3005
R1238 VIN.n1065 VIN.n1104 6.3005
R1239 VIN.n984 VIN.n1065 6.3005
R1240 VIN.n1066 VIN.n1106 6.3005
R1241 VIN.n982 VIN.n1066 6.3005
R1242 VIN.n1067 VIN.n1108 6.3005
R1243 VIN.n980 VIN.n1067 6.3005
R1244 VIN.n1068 VIN.n1110 6.3005
R1245 VIN.n978 VIN.n1068 6.3005
R1246 VIN.n1069 VIN.n1112 6.3005
R1247 VIN.n976 VIN.n1069 6.3005
R1248 VIN.n1070 VIN.n1114 6.3005
R1249 VIN.n974 VIN.n1070 6.3005
R1250 VIN.n1071 VIN.n1116 6.3005
R1251 VIN.n972 VIN.n1071 6.3005
R1252 VIN.n1072 VIN.n1118 6.3005
R1253 VIN.n970 VIN.n1072 6.3005
R1254 VIN.n1073 VIN.n1120 6.3005
R1255 VIN.n968 VIN.n1073 6.3005
R1256 VIN.n1074 VIN.n1122 6.3005
R1257 VIN.n966 VIN.n1074 6.3005
R1258 VIN.n1075 VIN.n1124 6.3005
R1259 VIN.n964 VIN.n1075 6.3005
R1260 VIN.n1076 VIN.n1126 6.3005
R1261 VIN.n962 VIN.n1076 6.3005
R1262 VIN.n1077 VIN.n1128 6.3005
R1263 VIN.n960 VIN.n1077 6.3005
R1264 VIN.n1078 VIN.n1130 6.3005
R1265 VIN.n958 VIN.n1078 6.3005
R1266 VIN.n1079 VIN.n1132 6.3005
R1267 VIN.n956 VIN.n1079 6.3005
R1268 VIN.n1080 VIN.n1134 6.3005
R1269 VIN.n954 VIN.n1080 6.3005
R1270 VIN.n1081 VIN.n1136 6.3005
R1271 VIN.n952 VIN.n1081 6.3005
R1272 VIN.n1082 VIN.n1138 6.3005
R1273 VIN.n950 VIN.n1082 6.3005
R1274 VIN.n1083 VIN.n1140 6.3005
R1275 VIN.n948 VIN.n1083 6.3005
R1276 VIN.n1084 VIN.n1142 6.3005
R1277 VIN.n946 VIN.n1084 6.3005
R1278 VIN.n1085 VIN.n1144 6.3005
R1279 VIN.n944 VIN.n1085 6.3005
R1280 VIN.n1086 VIN.n1146 6.3005
R1281 VIN.n942 VIN.n1086 6.3005
R1282 VIN.n1087 VIN.n1148 6.3005
R1283 VIN.n940 VIN.n1087 6.3005
R1284 VIN.n1088 VIN.n1150 6.3005
R1285 VIN.n938 VIN.n1088 6.3005
R1286 VIN.n1089 VIN.n1152 6.3005
R1287 VIN.n936 VIN.n1089 6.3005
R1288 VIN.n1090 VIN.n1154 6.3005
R1289 VIN.n934 VIN.n1090 6.3005
R1290 VIN.n1091 VIN.n1156 6.3005
R1291 VIN.n932 VIN.n1091 6.3005
R1292 VIN.n1092 VIN.n1158 6.3005
R1293 VIN.n930 VIN.n1092 6.3005
R1294 VIN.n1093 VIN.n1160 6.3005
R1295 VIN.n928 VIN.n1093 6.3005
R1296 VIN.n1094 VIN.n1162 6.3005
R1297 VIN.n926 VIN.n1094 6.3005
R1298 VIN.n1095 VIN.n1164 6.3005
R1299 VIN.n924 VIN.n1095 6.3005
R1300 VIN.n1096 VIN.n1166 6.3005
R1301 VIN.n922 VIN.n1096 6.3005
R1302 VIN.n1097 VIN.n1168 6.3005
R1303 VIN.n920 VIN.n1097 6.3005
R1304 VIN.n1062 VIN.n1170 2.74306
R1305 VIN.n1099 VIN.n1098 6.3005
R1306 VIN.n1098 VIN.n1062 3.39462
R1307 VIN.n1098 VIN.n1097 14.0005
R1308 VIN.n1097 VIN.n1096 14.0005
R1309 VIN.n1096 VIN.n1095 14.0005
R1310 VIN.n1095 VIN.n1094 14.0005
R1311 VIN.n1094 VIN.n1093 14.0005
R1312 VIN.n1093 VIN.n1092 14.0005
R1313 VIN.n1092 VIN.n1091 14.0005
R1314 VIN.n1091 VIN.n1090 14.0005
R1315 VIN.n1090 VIN.n1089 14.0005
R1316 VIN.n1089 VIN.n1088 14.0005
R1317 VIN.n1088 VIN.n1087 14.0005
R1318 VIN.n1087 VIN.n1086 14.0005
R1319 VIN.n1086 VIN.n1085 14.0005
R1320 VIN.n1085 VIN.n1084 14.0005
R1321 VIN.n1084 VIN.n1083 14.0005
R1322 VIN.n1083 VIN.n1082 14.0005
R1323 VIN.n1082 VIN.n1081 14.0005
R1324 VIN.n1081 VIN.n1080 14.0005
R1325 VIN.n1080 VIN.n1079 14.0005
R1326 VIN.n1079 VIN.n1078 14.0005
R1327 VIN.n1078 VIN.n1077 14.0005
R1328 VIN.n1077 VIN.n1076 14.0005
R1329 VIN.n1076 VIN.n1075 14.0005
R1330 VIN.n1075 VIN.n1074 14.0005
R1331 VIN.n1074 VIN.n1073 14.0005
R1332 VIN.n1073 VIN.n1072 14.0005
R1333 VIN.n1072 VIN.n1071 14.0005
R1334 VIN.n1071 VIN.n1070 14.0005
R1335 VIN.n1070 VIN.n1069 14.0005
R1336 VIN.n1069 VIN.n1068 14.0005
R1337 VIN.n1068 VIN.n1067 14.0005
R1338 VIN.n1067 VIN.n1066 14.0005
R1339 VIN.n1066 VIN.n1065 14.0005
R1340 VIN.n1065 VIN.n1064 14.0005
R1341 VIN.n1064 VIN.n1063 14.0005
R1342 VIN.n988 VIN.n989 56.6322
R1343 VIN.n1100 VIN.n1101 6.3005
R1344 VIN.n991 VIN.n1101 6.3005
R1345 VIN.n1102 VIN.n1103 6.3005
R1346 VIN.n1060 VIN.n1103 6.3005
R1347 VIN.n1104 VIN.n1105 6.3005
R1348 VIN.n1058 VIN.n1105 6.3005
R1349 VIN.n1106 VIN.n1107 6.3005
R1350 VIN.n1056 VIN.n1107 6.3005
R1351 VIN.n1108 VIN.n1109 6.3005
R1352 VIN.n1054 VIN.n1109 6.3005
R1353 VIN.n1110 VIN.n1111 6.3005
R1354 VIN.n1052 VIN.n1111 6.3005
R1355 VIN.n1112 VIN.n1113 6.3005
R1356 VIN.n1050 VIN.n1113 6.3005
R1357 VIN.n1114 VIN.n1115 6.3005
R1358 VIN.n1048 VIN.n1115 6.3005
R1359 VIN.n1116 VIN.n1117 6.3005
R1360 VIN.n1046 VIN.n1117 6.3005
R1361 VIN.n1118 VIN.n1119 6.3005
R1362 VIN.n1044 VIN.n1119 6.3005
R1363 VIN.n1120 VIN.n1121 6.3005
R1364 VIN.n1042 VIN.n1121 6.3005
R1365 VIN.n1122 VIN.n1123 6.3005
R1366 VIN.n1040 VIN.n1123 6.3005
R1367 VIN.n1124 VIN.n1125 6.3005
R1368 VIN.n1038 VIN.n1125 6.3005
R1369 VIN.n1126 VIN.n1127 6.3005
R1370 VIN.n1036 VIN.n1127 6.3005
R1371 VIN.n1128 VIN.n1129 6.3005
R1372 VIN.n1034 VIN.n1129 6.3005
R1373 VIN.n1130 VIN.n1131 6.3005
R1374 VIN.n1032 VIN.n1131 6.3005
R1375 VIN.n1132 VIN.n1133 6.3005
R1376 VIN.n1030 VIN.n1133 6.3005
R1377 VIN.n1134 VIN.n1135 6.3005
R1378 VIN.n1028 VIN.n1135 6.3005
R1379 VIN.n1136 VIN.n1137 6.3005
R1380 VIN.n1026 VIN.n1137 6.3005
R1381 VIN.n1138 VIN.n1139 6.3005
R1382 VIN.n1024 VIN.n1139 6.3005
R1383 VIN.n1140 VIN.n1141 6.3005
R1384 VIN.n1022 VIN.n1141 6.3005
R1385 VIN.n1142 VIN.n1143 6.3005
R1386 VIN.n1020 VIN.n1143 6.3005
R1387 VIN.n1144 VIN.n1145 6.3005
R1388 VIN.n1018 VIN.n1145 6.3005
R1389 VIN.n1146 VIN.n1147 6.3005
R1390 VIN.n1016 VIN.n1147 6.3005
R1391 VIN.n1148 VIN.n1149 6.3005
R1392 VIN.n1014 VIN.n1149 6.3005
R1393 VIN.n1150 VIN.n1151 6.3005
R1394 VIN.n1012 VIN.n1151 6.3005
R1395 VIN.n1152 VIN.n1153 6.3005
R1396 VIN.n1010 VIN.n1153 6.3005
R1397 VIN.n1154 VIN.n1155 6.3005
R1398 VIN.n1008 VIN.n1155 6.3005
R1399 VIN.n1156 VIN.n1157 6.3005
R1400 VIN.n1006 VIN.n1157 6.3005
R1401 VIN.n1158 VIN.n1159 6.3005
R1402 VIN.n1004 VIN.n1159 6.3005
R1403 VIN.n1160 VIN.n1161 6.3005
R1404 VIN.n1002 VIN.n1161 6.3005
R1405 VIN.n1162 VIN.n1163 6.3005
R1406 VIN.n1000 VIN.n1163 6.3005
R1407 VIN.n1164 VIN.n1165 6.3005
R1408 VIN.n998 VIN.n1165 6.3005
R1409 VIN.n1166 VIN.n1167 6.3005
R1410 VIN.n996 VIN.n1167 6.3005
R1411 VIN.n1168 VIN.n1169 6.3005
R1412 VIN.n994 VIN.n1169 6.3005
R1413 VIN.n1170 VIN.n1171 6.3005
R1414 VIN.n1172 VIN.n1171 6.3005
R1415 VIN.n1173 VIN.n1171 130.113
R1416 VIN.n1171 VIN.n1169 14.0005
R1417 VIN.n1169 VIN.n1167 14.0005
R1418 VIN.n1167 VIN.n1165 14.0005
R1419 VIN.n1165 VIN.n1163 14.0005
R1420 VIN.n1163 VIN.n1161 14.0005
R1421 VIN.n1161 VIN.n1159 14.0005
R1422 VIN.n1159 VIN.n1157 14.0005
R1423 VIN.n1157 VIN.n1155 14.0005
R1424 VIN.n1155 VIN.n1153 14.0005
R1425 VIN.n1153 VIN.n1151 14.0005
R1426 VIN.n1151 VIN.n1149 14.0005
R1427 VIN.n1149 VIN.n1147 14.0005
R1428 VIN.n1147 VIN.n1145 14.0005
R1429 VIN.n1145 VIN.n1143 14.0005
R1430 VIN.n1143 VIN.n1141 14.0005
R1431 VIN.n1141 VIN.n1139 14.0005
R1432 VIN.n1139 VIN.n1137 14.0005
R1433 VIN.n1137 VIN.n1135 14.0005
R1434 VIN.n1135 VIN.n1133 14.0005
R1435 VIN.n1133 VIN.n1131 14.0005
R1436 VIN.n1131 VIN.n1129 14.0005
R1437 VIN.n1129 VIN.n1127 14.0005
R1438 VIN.n1127 VIN.n1125 14.0005
R1439 VIN.n1125 VIN.n1123 14.0005
R1440 VIN.n1123 VIN.n1121 14.0005
R1441 VIN.n1121 VIN.n1119 14.0005
R1442 VIN.n1119 VIN.n1117 14.0005
R1443 VIN.n1117 VIN.n1115 14.0005
R1444 VIN.n1115 VIN.n1113 14.0005
R1445 VIN.n1113 VIN.n1111 14.0005
R1446 VIN.n1111 VIN.n1109 14.0005
R1447 VIN.n1109 VIN.n1107 14.0005
R1448 VIN.n1107 VIN.n1105 14.0005
R1449 VIN.n1105 VIN.n1103 14.0005
R1450 VIN.n1103 VIN.n1101 14.0005
R1451 VIN.n1101 VIN.n989 130.113
R1452 VIN.n994 VIN.n1172 0.1445
R1453 VIN.n996 VIN.n994 0.1445
R1454 VIN.n998 VIN.n996 0.1445
R1455 VIN.n1000 VIN.n998 0.1445
R1456 VIN.n1002 VIN.n1000 0.1445
R1457 VIN.n1002 VIN.n1004 0.1445
R1458 VIN.n1004 VIN.n1006 0.1445
R1459 VIN.n1006 VIN.n1008 0.1445
R1460 VIN.n1008 VIN.n1010 0.1445
R1461 VIN.n1010 VIN.n1012 0.1445
R1462 VIN.n1012 VIN.n1014 0.1445
R1463 VIN.n1014 VIN.n1016 0.1445
R1464 VIN.n1016 VIN.n1018 0.1445
R1465 VIN.n1018 VIN.n1020 0.1445
R1466 VIN.n1020 VIN.n1022 0.1445
R1467 VIN.n1022 VIN.n1024 0.1445
R1468 VIN.n1024 VIN.n1026 0.1445
R1469 VIN.n1026 VIN.n1028 0.1445
R1470 VIN.n1028 VIN.n1030 0.1445
R1471 VIN.n1030 VIN.n1032 0.1445
R1472 VIN.n1032 VIN.n1034 0.1445
R1473 VIN.n1034 VIN.n1036 0.1445
R1474 VIN.n1038 VIN.n1036 0.1445
R1475 VIN.n1038 VIN.n1040 0.1445
R1476 VIN.n1040 VIN.n1042 0.1445
R1477 VIN.n1042 VIN.n1044 0.1445
R1478 VIN.n1044 VIN.n1046 0.1445
R1479 VIN.n1046 VIN.n1048 0.1445
R1480 VIN.n1048 VIN.n1050 0.1445
R1481 VIN.n1050 VIN.n1052 0.1445
R1482 VIN.n1052 VIN.n1054 0.1445
R1483 VIN.n1056 VIN.n1054 0.1445
R1484 VIN.n1056 VIN.n1058 0.1445
R1485 VIN.n1060 VIN.n1058 0.1445
R1486 VIN.n991 VIN.n1060 0.1445
R1487 VIN.n1173 VIN.n1062 56.6322
R1488 VIN.n1170 VIN.n1168 59.9256
R1489 VIN.n1168 VIN.t114 56.1803
R1490 VIN.n1166 VIN.t114 3.74582
R1491 VIN.n1166 VIN.n1164 59.9256
R1492 VIN.n1164 VIN.n1162 59.9256
R1493 VIN.n1162 VIN.n1160 59.9256
R1494 VIN.n1160 VIN.n1158 59.9256
R1495 VIN.n1158 VIN.n1156 59.9256
R1496 VIN.n1156 VIN.n1154 59.9256
R1497 VIN.n1154 VIN.t249 14.2327
R1498 VIN.t249 VIN.n1152 45.6934
R1499 VIN.n1152 VIN.n1150 59.9256
R1500 VIN.n1150 VIN.n1148 59.9256
R1501 VIN.n1148 VIN.n1146 59.9256
R1502 VIN.n1146 VIN.n1144 59.9256
R1503 VIN.n1144 VIN.n1142 59.9256
R1504 VIN.n1142 VIN.t24 24.7196
R1505 VIN.t24 VIN.n1140 35.2065
R1506 VIN.n1140 VIN.n1138 59.9256
R1507 VIN.n1138 VIN.n1136 59.9256
R1508 VIN.n1136 VIN.n1134 59.9256
R1509 VIN.n1134 VIN.n1132 59.9256
R1510 VIN.n1132 VIN.n1130 59.9256
R1511 VIN.n1130 VIN.t274 35.2065
R1512 VIN.n1128 VIN.t274 24.7196
R1513 VIN.n1128 VIN.n1126 59.9256
R1514 VIN.n1126 VIN.n1124 59.9256
R1515 VIN.n1124 VIN.n1122 59.9256
R1516 VIN.n1122 VIN.n1120 59.9256
R1517 VIN.n1120 VIN.n1118 59.9256
R1518 VIN.n1118 VIN.t173 45.6934
R1519 VIN.n1116 VIN.t173 14.2327
R1520 VIN.n1116 VIN.n1114 59.9256
R1521 VIN.n1114 VIN.n1112 59.9256
R1522 VIN.n1112 VIN.n1110 59.9256
R1523 VIN.n1110 VIN.n1108 59.9256
R1524 VIN.n1108 VIN.n1106 59.9256
R1525 VIN.n1106 VIN.n1104 59.9256
R1526 VIN.n1104 VIN.t118 3.74582
R1527 VIN.t118 VIN.n1102 56.1803
R1528 VIN.n1102 VIN.n1100 59.9256
R1529 VIN.n988 VIN.n1100 2.74306
R1530 VIN.n920 VIN.n1099 0.1445
R1531 VIN.n922 VIN.n920 0.1445
R1532 VIN.n924 VIN.n922 0.1445
R1533 VIN.n924 VIN.n926 0.1445
R1534 VIN.n928 VIN.n926 0.1445
R1535 VIN.n930 VIN.n928 0.1445
R1536 VIN.n932 VIN.n930 0.1445
R1537 VIN.n932 VIN.n934 0.1445
R1538 VIN.n936 VIN.n934 0.1445
R1539 VIN.n938 VIN.n936 0.1445
R1540 VIN.n940 VIN.n938 0.1445
R1541 VIN.n942 VIN.n940 0.1445
R1542 VIN.n944 VIN.n942 0.1445
R1543 VIN.n946 VIN.n944 0.1445
R1544 VIN.n948 VIN.n946 0.1445
R1545 VIN.n950 VIN.n948 0.1445
R1546 VIN.n952 VIN.n950 0.1445
R1547 VIN.n954 VIN.n952 0.1445
R1548 VIN.n956 VIN.n954 0.1445
R1549 VIN.n958 VIN.n956 0.1445
R1550 VIN.n958 VIN.n960 0.1445
R1551 VIN.n960 VIN.n962 0.1445
R1552 VIN.n962 VIN.n964 0.1445
R1553 VIN.n966 VIN.n964 0.1445
R1554 VIN.n968 VIN.n966 0.1445
R1555 VIN.n970 VIN.n968 0.1445
R1556 VIN.n972 VIN.n970 0.1445
R1557 VIN.n974 VIN.n972 0.1445
R1558 VIN.n976 VIN.n974 0.1445
R1559 VIN.n976 VIN.n978 0.1445
R1560 VIN.n978 VIN.n980 0.1445
R1561 VIN.n980 VIN.n982 0.1445
R1562 VIN.n982 VIN.n984 0.1445
R1563 VIN.n984 VIN.n986 0.1445
R1564 VIN.n986 VIN.n917 0.1445
R1565 VIN.n777 VIN.n916 9.48839
R1566 VIN.n779 VIN.n778 4.5005
R1567 VIN.n780 VIN.n870 4.5005
R1568 VIN.n782 VIN.n781 4.5005
R1569 VIN.n784 VIN.n783 4.5005
R1570 VIN.n786 VIN.n785 4.5005
R1571 VIN.n788 VIN.n787 4.5005
R1572 VIN.n789 VIN.n790 4.5005
R1573 VIN.n791 VIN.n792 4.5005
R1574 VIN.n793 VIN.n794 4.5005
R1575 VIN.n795 VIN.n796 4.5005
R1576 VIN.n797 VIN.n798 4.5005
R1577 VIN.n799 VIN.n800 4.5005
R1578 VIN.n801 VIN.n802 4.5005
R1579 VIN.n803 VIN.n804 4.5005
R1580 VIN.n805 VIN.n806 4.5005
R1581 VIN.n807 VIN.n808 4.5005
R1582 VIN.n810 VIN.n809 4.5005
R1583 VIN.n812 VIN.n811 4.5005
R1584 VIN.n782 VIN.n780 0.1445
R1585 VIN.n784 VIN.n782 0.1445
R1586 VIN.n786 VIN.n784 0.1445
R1587 VIN.n788 VIN.n786 0.1445
R1588 VIN.n790 VIN.n788 0.1445
R1589 VIN.n792 VIN.n790 0.1445
R1590 VIN.n794 VIN.n792 0.1445
R1591 VIN.n796 VIN.n794 0.1445
R1592 VIN.n798 VIN.n796 0.1445
R1593 VIN.n800 VIN.n798 0.1445
R1594 VIN.n802 VIN.n800 0.1445
R1595 VIN.n804 VIN.n802 0.1445
R1596 VIN.n806 VIN.n804 0.1445
R1597 VIN.n808 VIN.n806 0.1445
R1598 VIN.n810 VIN.n808 0.1445
R1599 VIN.n812 VIN.n810 0.1445
R1600 VIN.n779 VIN.n812 0.1445
R1601 VIN.n916 VIN.n779 0.1481
R1602 VIN.n916 VIN.n913 4.97734
R1603 VIN.n915 VIN.n914 0.109087
R1604 VIN.n913 VIN.n915 0.229413
R1605 VIN.n914 VIN.t111 2.48461
R1606 VIN.n915 VIN.t112 2.37602
R1607 VIN.n914 VIN.t109 31.7385
R1608 VIN.n815 VIN.n814 0.332079
R1609 VIN.n913 VIN.n815 0.473978
R1610 VIN.n815 VIN.n817 5.68842
R1611 VIN.n817 VIN.n816 4.5005
R1612 VIN.n907 VIN.n818 4.5005
R1613 VIN.n819 VIN.n820 4.5005
R1614 VIN.n821 VIN.n822 4.5005
R1615 VIN.n823 VIN.n824 4.5005
R1616 VIN.n825 VIN.n826 4.5005
R1617 VIN.n827 VIN.n828 4.5005
R1618 VIN.n830 VIN.n829 4.5005
R1619 VIN.n831 VIN.n832 4.5005
R1620 VIN.n833 VIN.n834 4.5005
R1621 VIN.n835 VIN.n836 4.5005
R1622 VIN.n837 VIN.n838 4.5005
R1623 VIN.n839 VIN.n840 4.5005
R1624 VIN.n841 VIN.n842 4.5005
R1625 VIN.n843 VIN.n844 4.5005
R1626 VIN.n845 VIN.n846 4.5005
R1627 VIN.n847 VIN.n848 4.5005
R1628 VIN.n849 VIN.n850 4.5005
R1629 VIN.n820 VIN.n818 0.1445
R1630 VIN.n822 VIN.n820 0.1445
R1631 VIN.n824 VIN.n822 0.1445
R1632 VIN.n826 VIN.n824 0.1445
R1633 VIN.n828 VIN.n826 0.1445
R1634 VIN.n830 VIN.n828 0.1445
R1635 VIN.n832 VIN.n830 0.1445
R1636 VIN.n834 VIN.n832 0.1445
R1637 VIN.n836 VIN.n834 0.1445
R1638 VIN.n838 VIN.n836 0.1445
R1639 VIN.n840 VIN.n838 0.1445
R1640 VIN.n842 VIN.n840 0.1445
R1641 VIN.n844 VIN.n842 0.1445
R1642 VIN.n846 VIN.n844 0.1445
R1643 VIN.n848 VIN.n846 0.1445
R1644 VIN.n850 VIN.n848 0.1445
R1645 VIN.n817 VIN.n850 0.1445
R1646 VIN.n909 VIN.n908 0.332079
R1647 VIN.n910 VIN.n909 0.473978
R1648 VIN.n909 VIN.n818 5.68842
R1649 VIN.n910 VIN.n912 0.229413
R1650 VIN.n912 VIN.n911 0.109087
R1651 VIN.n912 VIN.t107 2.37602
R1652 VIN.n911 VIN.t108 2.48461
R1653 VIN.n911 VIN.t105 31.7385
R1654 VIN.n780 VIN.n910 5.12494
R1655 VIN.n852 VIN.n813 2.92361
R1656 VIN.n778 VIN.n852 6.3005
R1657 VIN.n853 VIN.n873 6.3005
R1658 VIN.n811 VIN.n853 6.3005
R1659 VIN.n854 VIN.n875 6.3005
R1660 VIN.n809 VIN.n854 6.3005
R1661 VIN.n855 VIN.n877 6.3005
R1662 VIN.n807 VIN.n855 6.3005
R1663 VIN.n856 VIN.n879 6.3005
R1664 VIN.n805 VIN.n856 6.3005
R1665 VIN.n857 VIN.n881 6.3005
R1666 VIN.n803 VIN.n857 6.3005
R1667 VIN.n858 VIN.n883 6.3005
R1668 VIN.n801 VIN.n858 6.3005
R1669 VIN.n859 VIN.n885 6.3005
R1670 VIN.n799 VIN.n859 6.3005
R1671 VIN.n860 VIN.n887 6.3005
R1672 VIN.n797 VIN.n860 6.3005
R1673 VIN.n861 VIN.n889 6.3005
R1674 VIN.n795 VIN.n861 6.3005
R1675 VIN.n862 VIN.n891 6.3005
R1676 VIN.n793 VIN.n862 6.3005
R1677 VIN.n863 VIN.n893 6.3005
R1678 VIN.n791 VIN.n863 6.3005
R1679 VIN.n864 VIN.n895 6.3005
R1680 VIN.n789 VIN.n864 6.3005
R1681 VIN.n865 VIN.n897 6.3005
R1682 VIN.n787 VIN.n865 6.3005
R1683 VIN.n866 VIN.n899 6.3005
R1684 VIN.n785 VIN.n866 6.3005
R1685 VIN.n867 VIN.n901 6.3005
R1686 VIN.n783 VIN.n867 6.3005
R1687 VIN.n868 VIN.n903 6.3005
R1688 VIN.n781 VIN.n868 6.3005
R1689 VIN.n851 VIN.n905 3.2039
R1690 VIN.n870 VIN.n869 6.3005
R1691 VIN.n869 VIN.n851 2.92361
R1692 VIN.n869 VIN.n868 14.0005
R1693 VIN.n868 VIN.n867 14.0005
R1694 VIN.n867 VIN.n866 14.0005
R1695 VIN.n866 VIN.n865 14.0005
R1696 VIN.n865 VIN.n864 14.0005
R1697 VIN.n864 VIN.n863 14.0005
R1698 VIN.n863 VIN.n862 14.0005
R1699 VIN.n862 VIN.n861 14.0005
R1700 VIN.n861 VIN.n860 14.0005
R1701 VIN.n860 VIN.n859 14.0005
R1702 VIN.n859 VIN.n858 14.0005
R1703 VIN.n858 VIN.n857 14.0005
R1704 VIN.n857 VIN.n856 14.0005
R1705 VIN.n856 VIN.n855 14.0005
R1706 VIN.n855 VIN.n854 14.0005
R1707 VIN.n854 VIN.n853 14.0005
R1708 VIN.n853 VIN.n852 14.0005
R1709 VIN.n813 VIN.n814 53.6496
R1710 VIN.n871 VIN.n872 6.3005
R1711 VIN.n816 VIN.n872 6.3005
R1712 VIN.n873 VIN.n874 6.3005
R1713 VIN.n849 VIN.n874 6.3005
R1714 VIN.n875 VIN.n876 6.3005
R1715 VIN.n847 VIN.n876 6.3005
R1716 VIN.n877 VIN.n878 6.3005
R1717 VIN.n845 VIN.n878 6.3005
R1718 VIN.n879 VIN.n880 6.3005
R1719 VIN.n843 VIN.n880 6.3005
R1720 VIN.n881 VIN.n882 6.3005
R1721 VIN.n841 VIN.n882 6.3005
R1722 VIN.n883 VIN.n884 6.3005
R1723 VIN.n839 VIN.n884 6.3005
R1724 VIN.n885 VIN.n886 6.3005
R1725 VIN.n837 VIN.n886 6.3005
R1726 VIN.n887 VIN.n888 6.3005
R1727 VIN.n835 VIN.n888 6.3005
R1728 VIN.n889 VIN.n890 6.3005
R1729 VIN.n833 VIN.n890 6.3005
R1730 VIN.n891 VIN.n892 6.3005
R1731 VIN.n831 VIN.n892 6.3005
R1732 VIN.n893 VIN.n894 6.3005
R1733 VIN.n829 VIN.n894 6.3005
R1734 VIN.n895 VIN.n896 6.3005
R1735 VIN.n827 VIN.n896 6.3005
R1736 VIN.n897 VIN.n898 6.3005
R1737 VIN.n825 VIN.n898 6.3005
R1738 VIN.n899 VIN.n900 6.3005
R1739 VIN.n823 VIN.n900 6.3005
R1740 VIN.n901 VIN.n902 6.3005
R1741 VIN.n821 VIN.n902 6.3005
R1742 VIN.n903 VIN.n904 6.3005
R1743 VIN.n819 VIN.n904 6.3005
R1744 VIN.n905 VIN.n906 6.3005
R1745 VIN.n907 VIN.n906 6.3005
R1746 VIN.n908 VIN.n906 105.525
R1747 VIN.n906 VIN.n904 14.0005
R1748 VIN.n904 VIN.n902 14.0005
R1749 VIN.n902 VIN.n900 14.0005
R1750 VIN.n900 VIN.n898 14.0005
R1751 VIN.n898 VIN.n896 14.0005
R1752 VIN.n896 VIN.n894 14.0005
R1753 VIN.n894 VIN.n892 14.0005
R1754 VIN.n892 VIN.n890 14.0005
R1755 VIN.n890 VIN.n888 14.0005
R1756 VIN.n888 VIN.n886 14.0005
R1757 VIN.n886 VIN.n884 14.0005
R1758 VIN.n884 VIN.n882 14.0005
R1759 VIN.n882 VIN.n880 14.0005
R1760 VIN.n880 VIN.n878 14.0005
R1761 VIN.n878 VIN.n876 14.0005
R1762 VIN.n876 VIN.n874 14.0005
R1763 VIN.n874 VIN.n872 14.0005
R1764 VIN.n872 VIN.n814 105.525
R1765 VIN.n819 VIN.n907 0.1445
R1766 VIN.n821 VIN.n819 0.1445
R1767 VIN.n823 VIN.n821 0.1445
R1768 VIN.n825 VIN.n823 0.1445
R1769 VIN.n827 VIN.n825 0.1445
R1770 VIN.n829 VIN.n827 0.1445
R1771 VIN.n829 VIN.n831 0.1445
R1772 VIN.n833 VIN.n831 0.1445
R1773 VIN.n835 VIN.n833 0.1445
R1774 VIN.n837 VIN.n835 0.1445
R1775 VIN.n839 VIN.n837 0.1445
R1776 VIN.n841 VIN.n839 0.1445
R1777 VIN.n843 VIN.n841 0.1445
R1778 VIN.n845 VIN.n843 0.1445
R1779 VIN.n847 VIN.n845 0.1445
R1780 VIN.n849 VIN.n847 0.1445
R1781 VIN.n816 VIN.n849 0.1445
R1782 VIN.n908 VIN.n851 53.6496
R1783 VIN.n905 VIN.t106 43.8197
R1784 VIN.n903 VIN.t106 29.9821
R1785 VIN.n903 VIN.n901 73.8012
R1786 VIN.n901 VIN.n899 73.8012
R1787 VIN.n899 VIN.t32 61.3474
R1788 VIN.n897 VIN.t32 12.4544
R1789 VIN.n897 VIN.n895 73.8012
R1790 VIN.n895 VIN.n893 73.8012
R1791 VIN.n893 VIN.t45 69.6499
R1792 VIN.n891 VIN.t45 4.15179
R1793 VIN.n891 VIN.n889 73.8012
R1794 VIN.n889 VIN.n887 73.8012
R1795 VIN.n887 VIN.n885 73.8012
R1796 VIN.n885 VIN.t33 4.15179
R1797 VIN.t33 VIN.n883 69.6499
R1798 VIN.n883 VIN.n881 73.8012
R1799 VIN.n881 VIN.n879 73.8012
R1800 VIN.n879 VIN.t15 12.4544
R1801 VIN.t15 VIN.n877 61.3474
R1802 VIN.n877 VIN.n875 73.8012
R1803 VIN.n875 VIN.n873 73.8012
R1804 VIN.n873 VIN.t110 29.9821
R1805 VIN.t110 VIN.n871 43.8197
R1806 VIN.n813 VIN.n871 3.2039
R1807 VIN.n870 VIN.n781 0.1445
R1808 VIN.n781 VIN.n783 0.1445
R1809 VIN.n783 VIN.n785 0.1445
R1810 VIN.n785 VIN.n787 0.1445
R1811 VIN.n787 VIN.n789 0.1445
R1812 VIN.n791 VIN.n789 0.1445
R1813 VIN.n793 VIN.n791 0.1445
R1814 VIN.n795 VIN.n793 0.1445
R1815 VIN.n797 VIN.n795 0.1445
R1816 VIN.n799 VIN.n797 0.1445
R1817 VIN.n801 VIN.n799 0.1445
R1818 VIN.n803 VIN.n801 0.1445
R1819 VIN.n805 VIN.n803 0.1445
R1820 VIN.n807 VIN.n805 0.1445
R1821 VIN.n809 VIN.n807 0.1445
R1822 VIN.n809 VIN.n811 0.1445
R1823 VIN.n811 VIN.n778 0.1445
R1824 VIN.n755 VIN.n776 9.48839
R1825 VIN.n757 VIN.n756 4.5005
R1826 VIN.n758 VIN.n768 4.5005
R1827 VIN.n757 VIN.n758 0.1445
R1828 VIN.n776 VIN.n757 0.1715
R1829 VIN.n761 VIN.n760 0.39425
R1830 VIN.n776 VIN.n761 5.46565
R1831 VIN.n761 VIN.n763 5.63665
R1832 VIN.n763 VIN.n762 4.5005
R1833 VIN.n773 VIN.n764 4.5005
R1834 VIN.n763 VIN.n764 0.1445
R1835 VIN.n775 VIN.n774 0.39425
R1836 VIN.n775 VIN.n764 5.63665
R1837 VIN.n758 VIN.n775 5.63665
R1838 VIN.n766 VIN.n759 2.61539
R1839 VIN.n756 VIN.n766 6.3005
R1840 VIN.n765 VIN.n771 3.52363
R1841 VIN.n768 VIN.n767 6.3005
R1842 VIN.n767 VIN.n765 2.61539
R1843 VIN.n767 VIN.n766 14.0005
R1844 VIN.n759 VIN.n760 56.5099
R1845 VIN.n769 VIN.n770 6.3005
R1846 VIN.n762 VIN.n770 6.3005
R1847 VIN.n771 VIN.n772 6.3005
R1848 VIN.n773 VIN.n772 6.3005
R1849 VIN.n774 VIN.n772 101.062
R1850 VIN.n772 VIN.n770 14.0005
R1851 VIN.n770 VIN.n760 101.062
R1852 VIN.n762 VIN.n773 0.1445
R1853 VIN.n774 VIN.n765 56.5099
R1854 VIN.n771 VIN.t171 39.6437
R1855 VIN.n769 VIN.t171 39.6437
R1856 VIN.n759 VIN.n769 3.52363
R1857 VIN.n768 VIN.n756 0.1445
R1858 VIN.n719 VIN.n754 9.48839
R1859 VIN.n721 VIN.n720 4.5005
R1860 VIN.n742 VIN.n722 4.5005
R1861 VIN.n724 VIN.n723 4.5005
R1862 VIN.n725 VIN.n726 4.5005
R1863 VIN.n724 VIN.n722 0.1445
R1864 VIN.n726 VIN.n724 0.1445
R1865 VIN.n721 VIN.n726 0.1445
R1866 VIN.n754 VIN.n721 0.1301
R1867 VIN.n729 VIN.n728 0.39425
R1868 VIN.n754 VIN.n729 5.46745
R1869 VIN.n729 VIN.n731 5.59705
R1870 VIN.n731 VIN.n730 4.5005
R1871 VIN.n732 VIN.n751 4.5005
R1872 VIN.n734 VIN.n733 4.5005
R1873 VIN.n736 VIN.n735 4.5005
R1874 VIN.n734 VIN.n732 0.1445
R1875 VIN.n736 VIN.n734 0.1445
R1876 VIN.n731 VIN.n736 0.1445
R1877 VIN.n753 VIN.n752 0.39425
R1878 VIN.n753 VIN.n732 5.59705
R1879 VIN.n722 VIN.n753 5.59705
R1880 VIN.n738 VIN.n727 2.81189
R1881 VIN.n720 VIN.n738 6.3005
R1882 VIN.n739 VIN.n745 6.3005
R1883 VIN.n725 VIN.n739 6.3005
R1884 VIN.n740 VIN.n747 6.3005
R1885 VIN.n723 VIN.n740 6.3005
R1886 VIN.n737 VIN.n749 3.30794
R1887 VIN.n742 VIN.n741 6.3005
R1888 VIN.n741 VIN.n737 2.81189
R1889 VIN.n741 VIN.n740 14.0005
R1890 VIN.n740 VIN.n739 14.0005
R1891 VIN.n739 VIN.n738 14.0005
R1892 VIN.n727 VIN.n728 51.029
R1893 VIN.n743 VIN.n744 6.3005
R1894 VIN.n730 VIN.n744 6.3005
R1895 VIN.n745 VIN.n746 6.3005
R1896 VIN.n735 VIN.n746 6.3005
R1897 VIN.n747 VIN.n748 6.3005
R1898 VIN.n733 VIN.n748 6.3005
R1899 VIN.n749 VIN.n750 6.3005
R1900 VIN.n751 VIN.n750 6.3005
R1901 VIN.n752 VIN.n750 97.213
R1902 VIN.n750 VIN.n748 14.0005
R1903 VIN.n748 VIN.n746 14.0005
R1904 VIN.n746 VIN.n744 14.0005
R1905 VIN.n744 VIN.n728 97.213
R1906 VIN.n751 VIN.n733 0.1445
R1907 VIN.n733 VIN.n735 0.1445
R1908 VIN.n735 VIN.n730 0.1445
R1909 VIN.n752 VIN.n737 51.029
R1910 VIN.n749 VIN.t263 61.4475
R1911 VIN.n747 VIN.t263 17.8399
R1912 VIN.n747 VIN.n745 79.2869
R1913 VIN.n745 VIN.t265 17.8399
R1914 VIN.t265 VIN.n743 61.4475
R1915 VIN.n727 VIN.n743 3.30794
R1916 VIN.n723 VIN.n742 0.1445
R1917 VIN.n723 VIN.n725 0.1445
R1918 VIN.n720 VIN.n725 0.1445
R1919 VIN.n697 VIN.n718 9.48839
R1920 VIN.n699 VIN.n698 4.5005
R1921 VIN.n710 VIN.n700 4.5005
R1922 VIN.n699 VIN.n700 0.1445
R1923 VIN.n718 VIN.n699 0.1715
R1924 VIN.n703 VIN.n702 0.39425
R1925 VIN.n718 VIN.n703 5.46565
R1926 VIN.n703 VIN.n705 5.63665
R1927 VIN.n705 VIN.n704 4.5005
R1928 VIN.n706 VIN.n715 4.5005
R1929 VIN.n705 VIN.n706 0.1445
R1930 VIN.n717 VIN.n716 0.39425
R1931 VIN.n717 VIN.n706 5.63665
R1932 VIN.n700 VIN.n717 5.63665
R1933 VIN.n708 VIN.n701 2.61539
R1934 VIN.n698 VIN.n708 6.3005
R1935 VIN.n707 VIN.n713 3.52363
R1936 VIN.n710 VIN.n709 6.3005
R1937 VIN.n709 VIN.n707 2.61539
R1938 VIN.n709 VIN.n708 14.0005
R1939 VIN.n701 VIN.n702 56.5099
R1940 VIN.n711 VIN.n712 6.3005
R1941 VIN.n704 VIN.n712 6.3005
R1942 VIN.n713 VIN.n714 6.3005
R1943 VIN.n715 VIN.n714 6.3005
R1944 VIN.n716 VIN.n714 101.062
R1945 VIN.n714 VIN.n712 14.0005
R1946 VIN.n712 VIN.n702 101.062
R1947 VIN.n715 VIN.n704 0.1445
R1948 VIN.n716 VIN.n707 56.5099
R1949 VIN.n713 VIN.t261 39.6437
R1950 VIN.n711 VIN.t261 39.6437
R1951 VIN.n701 VIN.n711 3.52363
R1952 VIN.n698 VIN.n710 0.1445
R1953 VIN.n696 VIN.t10 20.1227
R1954 VIN.n695 VIN.t103 20.1227
R1955 VIN.n333 VIN.n332 4.5005
R1956 VIN.n334 VIN.n589 4.5005
R1957 VIN.n335 VIN.n336 4.5005
R1958 VIN.n338 VIN.n337 4.5005
R1959 VIN.n340 VIN.n339 4.5005
R1960 VIN.n341 VIN.n342 4.5005
R1961 VIN.n343 VIN.n344 4.5005
R1962 VIN.n345 VIN.n346 4.5005
R1963 VIN.n347 VIN.n348 4.5005
R1964 VIN.n349 VIN.n350 4.5005
R1965 VIN.n351 VIN.n352 4.5005
R1966 VIN.n354 VIN.n353 4.5005
R1967 VIN.n355 VIN.n356 4.5005
R1968 VIN.n358 VIN.n357 4.5005
R1969 VIN.n359 VIN.n360 4.5005
R1970 VIN.n361 VIN.n362 4.5005
R1971 VIN.n363 VIN.n364 4.5005
R1972 VIN.n366 VIN.n365 4.5005
R1973 VIN.n367 VIN.n368 4.5005
R1974 VIN.n369 VIN.n370 4.5005
R1975 VIN.n371 VIN.n372 4.5005
R1976 VIN.n373 VIN.n374 4.5005
R1977 VIN.n375 VIN.n376 4.5005
R1978 VIN.n377 VIN.n378 4.5005
R1979 VIN.n379 VIN.n380 4.5005
R1980 VIN.n381 VIN.n382 4.5005
R1981 VIN.n383 VIN.n384 4.5005
R1982 VIN.n385 VIN.n386 4.5005
R1983 VIN.n387 VIN.n388 4.5005
R1984 VIN.n389 VIN.n390 4.5005
R1985 VIN.n391 VIN.n392 4.5005
R1986 VIN.n393 VIN.n394 4.5005
R1987 VIN.n395 VIN.n396 4.5005
R1988 VIN.n397 VIN.n398 4.5005
R1989 VIN.n399 VIN.n400 4.5005
R1990 VIN.n401 VIN.n402 4.5005
R1991 VIN.n404 VIN.n403 4.5005
R1992 VIN.n406 VIN.n405 4.5005
R1993 VIN.n408 VIN.n407 4.5005
R1994 VIN.n410 VIN.n409 4.5005
R1995 VIN.n412 VIN.n411 4.5005
R1996 VIN.n414 VIN.n413 4.5005
R1997 VIN.n416 VIN.n415 4.5005
R1998 VIN.n418 VIN.n417 4.5005
R1999 VIN.n420 VIN.n419 4.5005
R2000 VIN.n422 VIN.n421 4.5005
R2001 VIN.n424 VIN.n423 4.5005
R2002 VIN.n426 VIN.n425 4.5005
R2003 VIN.n428 VIN.n427 4.5005
R2004 VIN.n430 VIN.n429 4.5005
R2005 VIN.n432 VIN.n431 4.5005
R2006 VIN.n336 VIN.n334 0.1445
R2007 VIN.n338 VIN.n336 0.1445
R2008 VIN.n340 VIN.n338 0.1445
R2009 VIN.n342 VIN.n340 0.1445
R2010 VIN.n344 VIN.n342 0.1445
R2011 VIN.n346 VIN.n344 0.1445
R2012 VIN.n348 VIN.n346 0.1445
R2013 VIN.n350 VIN.n348 0.1445
R2014 VIN.n352 VIN.n350 0.1445
R2015 VIN.n354 VIN.n352 0.1445
R2016 VIN.n356 VIN.n354 0.1445
R2017 VIN.n358 VIN.n356 0.1445
R2018 VIN.n360 VIN.n358 0.1445
R2019 VIN.n362 VIN.n360 0.1445
R2020 VIN.n364 VIN.n362 0.1445
R2021 VIN.n366 VIN.n364 0.1445
R2022 VIN.n368 VIN.n366 0.1445
R2023 VIN.n370 VIN.n368 0.1445
R2024 VIN.n372 VIN.n370 0.1445
R2025 VIN.n374 VIN.n372 0.1445
R2026 VIN.n376 VIN.n374 0.1445
R2027 VIN.n378 VIN.n376 0.1445
R2028 VIN.n380 VIN.n378 0.1445
R2029 VIN.n382 VIN.n380 0.1445
R2030 VIN.n384 VIN.n382 0.1445
R2031 VIN.n386 VIN.n384 0.1445
R2032 VIN.n388 VIN.n386 0.1445
R2033 VIN.n390 VIN.n388 0.1445
R2034 VIN.n392 VIN.n390 0.1445
R2035 VIN.n394 VIN.n392 0.1445
R2036 VIN.n396 VIN.n394 0.1445
R2037 VIN.n398 VIN.n396 0.1445
R2038 VIN.n400 VIN.n398 0.1445
R2039 VIN.n402 VIN.n400 0.1445
R2040 VIN.n404 VIN.n402 0.1445
R2041 VIN.n406 VIN.n404 0.1445
R2042 VIN.n408 VIN.n406 0.1445
R2043 VIN.n410 VIN.n408 0.1445
R2044 VIN.n412 VIN.n410 0.1445
R2045 VIN.n414 VIN.n412 0.1445
R2046 VIN.n416 VIN.n414 0.1445
R2047 VIN.n418 VIN.n416 0.1445
R2048 VIN.n420 VIN.n418 0.1445
R2049 VIN.n422 VIN.n420 0.1445
R2050 VIN.n424 VIN.n422 0.1445
R2051 VIN.n426 VIN.n424 0.1445
R2052 VIN.n428 VIN.n426 0.1445
R2053 VIN.n430 VIN.n428 0.1445
R2054 VIN.n432 VIN.n430 0.1445
R2055 VIN.n333 VIN.n432 0.1445
R2056 VIN.n694 VIN.n333 0.1895
R2057 VIN.n435 VIN.n434 0.788
R2058 VIN.n694 VIN.n435 5.07533
R2059 VIN.n435 VIN.n437 5.26433
R2060 VIN.n437 VIN.n436 4.5005
R2061 VIN.n691 VIN.n438 4.5005
R2062 VIN.n439 VIN.n440 4.5005
R2063 VIN.n441 VIN.n442 4.5005
R2064 VIN.n443 VIN.n444 4.5005
R2065 VIN.n445 VIN.n446 4.5005
R2066 VIN.n447 VIN.n448 4.5005
R2067 VIN.n449 VIN.n450 4.5005
R2068 VIN.n452 VIN.n451 4.5005
R2069 VIN.n453 VIN.n454 4.5005
R2070 VIN.n455 VIN.n456 4.5005
R2071 VIN.n457 VIN.n458 4.5005
R2072 VIN.n459 VIN.n460 4.5005
R2073 VIN.n462 VIN.n461 4.5005
R2074 VIN.n463 VIN.n464 4.5005
R2075 VIN.n465 VIN.n466 4.5005
R2076 VIN.n467 VIN.n468 4.5005
R2077 VIN.n469 VIN.n470 4.5005
R2078 VIN.n471 VIN.n472 4.5005
R2079 VIN.n473 VIN.n474 4.5005
R2080 VIN.n475 VIN.n476 4.5005
R2081 VIN.n477 VIN.n478 4.5005
R2082 VIN.n480 VIN.n479 4.5005
R2083 VIN.n481 VIN.n482 4.5005
R2084 VIN.n484 VIN.n483 4.5005
R2085 VIN.n486 VIN.n485 4.5005
R2086 VIN.n487 VIN.n488 4.5005
R2087 VIN.n489 VIN.n490 4.5005
R2088 VIN.n491 VIN.n492 4.5005
R2089 VIN.n493 VIN.n494 4.5005
R2090 VIN.n495 VIN.n496 4.5005
R2091 VIN.n497 VIN.n498 4.5005
R2092 VIN.n499 VIN.n500 4.5005
R2093 VIN.n501 VIN.n502 4.5005
R2094 VIN.n503 VIN.n504 4.5005
R2095 VIN.n505 VIN.n506 4.5005
R2096 VIN.n507 VIN.n508 4.5005
R2097 VIN.n510 VIN.n509 4.5005
R2098 VIN.n511 VIN.n512 4.5005
R2099 VIN.n513 VIN.n514 4.5005
R2100 VIN.n515 VIN.n516 4.5005
R2101 VIN.n517 VIN.n518 4.5005
R2102 VIN.n519 VIN.n520 4.5005
R2103 VIN.n521 VIN.n522 4.5005
R2104 VIN.n524 VIN.n523 4.5005
R2105 VIN.n525 VIN.n526 4.5005
R2106 VIN.n528 VIN.n527 4.5005
R2107 VIN.n529 VIN.n530 4.5005
R2108 VIN.n531 VIN.n532 4.5005
R2109 VIN.n533 VIN.n534 4.5005
R2110 VIN.n536 VIN.n535 4.5005
R2111 VIN.n440 VIN.n438 0.1445
R2112 VIN.n442 VIN.n440 0.1445
R2113 VIN.n444 VIN.n442 0.1445
R2114 VIN.n446 VIN.n444 0.1445
R2115 VIN.n448 VIN.n446 0.1445
R2116 VIN.n450 VIN.n448 0.1445
R2117 VIN.n452 VIN.n450 0.1445
R2118 VIN.n454 VIN.n452 0.1445
R2119 VIN.n456 VIN.n454 0.1445
R2120 VIN.n458 VIN.n456 0.1445
R2121 VIN.n460 VIN.n458 0.1445
R2122 VIN.n462 VIN.n460 0.1445
R2123 VIN.n464 VIN.n462 0.1445
R2124 VIN.n466 VIN.n464 0.1445
R2125 VIN.n468 VIN.n466 0.1445
R2126 VIN.n470 VIN.n468 0.1445
R2127 VIN.n472 VIN.n470 0.1445
R2128 VIN.n474 VIN.n472 0.1445
R2129 VIN.n476 VIN.n474 0.1445
R2130 VIN.n478 VIN.n476 0.1445
R2131 VIN.n480 VIN.n478 0.1445
R2132 VIN.n482 VIN.n480 0.1445
R2133 VIN.n484 VIN.n482 0.1445
R2134 VIN.n486 VIN.n484 0.1445
R2135 VIN.n488 VIN.n486 0.1445
R2136 VIN.n490 VIN.n488 0.1445
R2137 VIN.n492 VIN.n490 0.1445
R2138 VIN.n494 VIN.n492 0.1445
R2139 VIN.n496 VIN.n494 0.1445
R2140 VIN.n498 VIN.n496 0.1445
R2141 VIN.n500 VIN.n498 0.1445
R2142 VIN.n502 VIN.n500 0.1445
R2143 VIN.n504 VIN.n502 0.1445
R2144 VIN.n506 VIN.n504 0.1445
R2145 VIN.n508 VIN.n506 0.1445
R2146 VIN.n510 VIN.n508 0.1445
R2147 VIN.n512 VIN.n510 0.1445
R2148 VIN.n514 VIN.n512 0.1445
R2149 VIN.n516 VIN.n514 0.1445
R2150 VIN.n518 VIN.n516 0.1445
R2151 VIN.n520 VIN.n518 0.1445
R2152 VIN.n522 VIN.n520 0.1445
R2153 VIN.n524 VIN.n522 0.1445
R2154 VIN.n526 VIN.n524 0.1445
R2155 VIN.n528 VIN.n526 0.1445
R2156 VIN.n530 VIN.n528 0.1445
R2157 VIN.n532 VIN.n530 0.1445
R2158 VIN.n534 VIN.n532 0.1445
R2159 VIN.n536 VIN.n534 0.1445
R2160 VIN.n437 VIN.n536 0.1445
R2161 VIN.n693 VIN.n692 0.788
R2162 VIN.n693 VIN.n438 5.26433
R2163 VIN.n334 VIN.n693 5.26433
R2164 VIN.n538 VIN.n433 1.35483
R2165 VIN.n332 VIN.n538 6.3005
R2166 VIN.n539 VIN.n592 6.3005
R2167 VIN.n431 VIN.n539 6.3005
R2168 VIN.n540 VIN.n594 6.3005
R2169 VIN.n429 VIN.n540 6.3005
R2170 VIN.n541 VIN.n596 6.3005
R2171 VIN.n427 VIN.n541 6.3005
R2172 VIN.n542 VIN.n598 6.3005
R2173 VIN.n425 VIN.n542 6.3005
R2174 VIN.n543 VIN.n600 6.3005
R2175 VIN.n423 VIN.n543 6.3005
R2176 VIN.n544 VIN.n602 6.3005
R2177 VIN.n421 VIN.n544 6.3005
R2178 VIN.n545 VIN.n604 6.3005
R2179 VIN.n419 VIN.n545 6.3005
R2180 VIN.n546 VIN.n606 6.3005
R2181 VIN.n417 VIN.n546 6.3005
R2182 VIN.n547 VIN.n608 6.3005
R2183 VIN.n415 VIN.n547 6.3005
R2184 VIN.n548 VIN.n610 6.3005
R2185 VIN.n413 VIN.n548 6.3005
R2186 VIN.n549 VIN.n612 6.3005
R2187 VIN.n411 VIN.n549 6.3005
R2188 VIN.n550 VIN.n614 6.3005
R2189 VIN.n409 VIN.n550 6.3005
R2190 VIN.n551 VIN.n616 6.3005
R2191 VIN.n407 VIN.n551 6.3005
R2192 VIN.n552 VIN.n618 6.3005
R2193 VIN.n405 VIN.n552 6.3005
R2194 VIN.n553 VIN.n620 6.3005
R2195 VIN.n403 VIN.n553 6.3005
R2196 VIN.n554 VIN.n622 6.3005
R2197 VIN.n401 VIN.n554 6.3005
R2198 VIN.n555 VIN.n624 6.3005
R2199 VIN.n399 VIN.n555 6.3005
R2200 VIN.n556 VIN.n626 6.3005
R2201 VIN.n397 VIN.n556 6.3005
R2202 VIN.n557 VIN.n628 6.3005
R2203 VIN.n395 VIN.n557 6.3005
R2204 VIN.n558 VIN.n630 6.3005
R2205 VIN.n393 VIN.n558 6.3005
R2206 VIN.n559 VIN.n632 6.3005
R2207 VIN.n391 VIN.n559 6.3005
R2208 VIN.n560 VIN.n634 6.3005
R2209 VIN.n389 VIN.n560 6.3005
R2210 VIN.n561 VIN.n636 6.3005
R2211 VIN.n387 VIN.n561 6.3005
R2212 VIN.n562 VIN.n638 6.3005
R2213 VIN.n385 VIN.n562 6.3005
R2214 VIN.n563 VIN.t268 6.3005
R2215 VIN.n383 VIN.n563 6.3005
R2216 VIN.n564 VIN.n641 6.3005
R2217 VIN.n381 VIN.n564 6.3005
R2218 VIN.n565 VIN.n643 6.3005
R2219 VIN.n379 VIN.n565 6.3005
R2220 VIN.n566 VIN.n645 6.3005
R2221 VIN.n377 VIN.n566 6.3005
R2222 VIN.n567 VIN.n647 6.3005
R2223 VIN.n375 VIN.n567 6.3005
R2224 VIN.n568 VIN.n649 6.3005
R2225 VIN.n373 VIN.n568 6.3005
R2226 VIN.n569 VIN.n651 6.3005
R2227 VIN.n371 VIN.n569 6.3005
R2228 VIN.n570 VIN.n653 6.3005
R2229 VIN.n369 VIN.n570 6.3005
R2230 VIN.n571 VIN.n655 6.3005
R2231 VIN.n367 VIN.n571 6.3005
R2232 VIN.n572 VIN.n657 6.3005
R2233 VIN.n365 VIN.n572 6.3005
R2234 VIN.n573 VIN.n659 6.3005
R2235 VIN.n363 VIN.n573 6.3005
R2236 VIN.n574 VIN.n661 6.3005
R2237 VIN.n361 VIN.n574 6.3005
R2238 VIN.n575 VIN.n663 6.3005
R2239 VIN.n359 VIN.n575 6.3005
R2240 VIN.n576 VIN.n665 6.3005
R2241 VIN.n357 VIN.n576 6.3005
R2242 VIN.n577 VIN.n667 6.3005
R2243 VIN.n355 VIN.n577 6.3005
R2244 VIN.n578 VIN.n669 6.3005
R2245 VIN.n353 VIN.n578 6.3005
R2246 VIN.n579 VIN.n671 6.3005
R2247 VIN.n351 VIN.n579 6.3005
R2248 VIN.n580 VIN.n673 6.3005
R2249 VIN.n349 VIN.n580 6.3005
R2250 VIN.n581 VIN.n675 6.3005
R2251 VIN.n347 VIN.n581 6.3005
R2252 VIN.n582 VIN.n677 6.3005
R2253 VIN.n345 VIN.n582 6.3005
R2254 VIN.n583 VIN.n679 6.3005
R2255 VIN.n343 VIN.n583 6.3005
R2256 VIN.n584 VIN.n681 6.3005
R2257 VIN.n341 VIN.n584 6.3005
R2258 VIN.n585 VIN.n683 6.3005
R2259 VIN.n339 VIN.n585 6.3005
R2260 VIN.n586 VIN.n685 6.3005
R2261 VIN.n337 VIN.n586 6.3005
R2262 VIN.n587 VIN.n687 6.3005
R2263 VIN.n335 VIN.n587 6.3005
R2264 VIN.n537 VIN.n689 4.82156
R2265 VIN.n589 VIN.n588 6.3005
R2266 VIN.n588 VIN.n537 1.35483
R2267 VIN.n588 VIN.n587 14.0005
R2268 VIN.n587 VIN.n586 14.0005
R2269 VIN.n586 VIN.n585 14.0005
R2270 VIN.n585 VIN.n584 14.0005
R2271 VIN.n584 VIN.n583 14.0005
R2272 VIN.n583 VIN.n582 14.0005
R2273 VIN.n582 VIN.n581 14.0005
R2274 VIN.n581 VIN.n580 14.0005
R2275 VIN.n580 VIN.n579 14.0005
R2276 VIN.n579 VIN.n578 14.0005
R2277 VIN.n578 VIN.n577 14.0005
R2278 VIN.n577 VIN.n576 14.0005
R2279 VIN.n576 VIN.n575 14.0005
R2280 VIN.n575 VIN.n574 14.0005
R2281 VIN.n574 VIN.n573 14.0005
R2282 VIN.n573 VIN.n572 14.0005
R2283 VIN.n572 VIN.n571 14.0005
R2284 VIN.n571 VIN.n570 14.0005
R2285 VIN.n570 VIN.n569 14.0005
R2286 VIN.n569 VIN.n568 14.0005
R2287 VIN.n568 VIN.n567 14.0005
R2288 VIN.n567 VIN.n566 14.0005
R2289 VIN.n566 VIN.n565 14.0005
R2290 VIN.n565 VIN.n564 14.0005
R2291 VIN.n564 VIN.n563 14.0005
R2292 VIN.n563 VIN.n562 14.0005
R2293 VIN.n562 VIN.n561 14.0005
R2294 VIN.n561 VIN.n560 14.0005
R2295 VIN.n560 VIN.n559 14.0005
R2296 VIN.n559 VIN.n558 14.0005
R2297 VIN.n558 VIN.n557 14.0005
R2298 VIN.n557 VIN.n556 14.0005
R2299 VIN.n556 VIN.n555 14.0005
R2300 VIN.n555 VIN.n554 14.0005
R2301 VIN.n554 VIN.n553 14.0005
R2302 VIN.n553 VIN.n552 14.0005
R2303 VIN.n552 VIN.n551 14.0005
R2304 VIN.n551 VIN.n550 14.0005
R2305 VIN.n550 VIN.n549 14.0005
R2306 VIN.n549 VIN.n548 14.0005
R2307 VIN.n548 VIN.n547 14.0005
R2308 VIN.n547 VIN.n546 14.0005
R2309 VIN.n546 VIN.n545 14.0005
R2310 VIN.n545 VIN.n544 14.0005
R2311 VIN.n544 VIN.n543 14.0005
R2312 VIN.n543 VIN.n542 14.0005
R2313 VIN.n542 VIN.n541 14.0005
R2314 VIN.n541 VIN.n540 14.0005
R2315 VIN.n540 VIN.n539 14.0005
R2316 VIN.n539 VIN.n538 14.0005
R2317 VIN.n433 VIN.n434 51.9559
R2318 VIN.n590 VIN.n591 6.3005
R2319 VIN.n436 VIN.n591 6.3005
R2320 VIN.n592 VIN.n593 6.3005
R2321 VIN.n535 VIN.n593 6.3005
R2322 VIN.n594 VIN.n595 6.3005
R2323 VIN.n533 VIN.n595 6.3005
R2324 VIN.n596 VIN.n597 6.3005
R2325 VIN.n531 VIN.n597 6.3005
R2326 VIN.n598 VIN.n599 6.3005
R2327 VIN.n529 VIN.n599 6.3005
R2328 VIN.n600 VIN.n601 6.3005
R2329 VIN.n527 VIN.n601 6.3005
R2330 VIN.n602 VIN.n603 6.3005
R2331 VIN.n525 VIN.n603 6.3005
R2332 VIN.n604 VIN.n605 6.3005
R2333 VIN.n523 VIN.n605 6.3005
R2334 VIN.n606 VIN.n607 6.3005
R2335 VIN.n521 VIN.n607 6.3005
R2336 VIN.n608 VIN.n609 6.3005
R2337 VIN.n519 VIN.n609 6.3005
R2338 VIN.n610 VIN.n611 6.3005
R2339 VIN.n517 VIN.n611 6.3005
R2340 VIN.n612 VIN.n613 6.3005
R2341 VIN.n515 VIN.n613 6.3005
R2342 VIN.n614 VIN.n615 6.3005
R2343 VIN.n513 VIN.n615 6.3005
R2344 VIN.n616 VIN.n617 6.3005
R2345 VIN.n511 VIN.n617 6.3005
R2346 VIN.n618 VIN.n619 6.3005
R2347 VIN.n509 VIN.n619 6.3005
R2348 VIN.n620 VIN.n621 6.3005
R2349 VIN.n507 VIN.n621 6.3005
R2350 VIN.n622 VIN.n623 6.3005
R2351 VIN.n505 VIN.n623 6.3005
R2352 VIN.n624 VIN.n625 6.3005
R2353 VIN.n503 VIN.n625 6.3005
R2354 VIN.n626 VIN.n627 6.3005
R2355 VIN.n501 VIN.n627 6.3005
R2356 VIN.n628 VIN.n629 6.3005
R2357 VIN.n499 VIN.n629 6.3005
R2358 VIN.n630 VIN.n631 6.3005
R2359 VIN.n497 VIN.n631 6.3005
R2360 VIN.n632 VIN.n633 6.3005
R2361 VIN.n495 VIN.n633 6.3005
R2362 VIN.n634 VIN.n635 6.3005
R2363 VIN.n493 VIN.n635 6.3005
R2364 VIN.n636 VIN.n637 6.3005
R2365 VIN.n491 VIN.n637 6.3005
R2366 VIN.n638 VIN.n639 6.3005
R2367 VIN.n489 VIN.n639 6.3005
R2368 VIN.t268 VIN.n640 6.3005
R2369 VIN.n487 VIN.n640 6.3005
R2370 VIN.n641 VIN.n642 6.3005
R2371 VIN.n485 VIN.n642 6.3005
R2372 VIN.n643 VIN.n644 6.3005
R2373 VIN.n483 VIN.n644 6.3005
R2374 VIN.n645 VIN.n646 6.3005
R2375 VIN.n481 VIN.n646 6.3005
R2376 VIN.n647 VIN.n648 6.3005
R2377 VIN.n479 VIN.n648 6.3005
R2378 VIN.n649 VIN.n650 6.3005
R2379 VIN.n477 VIN.n650 6.3005
R2380 VIN.n651 VIN.n652 6.3005
R2381 VIN.n475 VIN.n652 6.3005
R2382 VIN.n653 VIN.n654 6.3005
R2383 VIN.n473 VIN.n654 6.3005
R2384 VIN.n655 VIN.n656 6.3005
R2385 VIN.n471 VIN.n656 6.3005
R2386 VIN.n657 VIN.n658 6.3005
R2387 VIN.n469 VIN.n658 6.3005
R2388 VIN.n659 VIN.n660 6.3005
R2389 VIN.n467 VIN.n660 6.3005
R2390 VIN.n661 VIN.n662 6.3005
R2391 VIN.n465 VIN.n662 6.3005
R2392 VIN.n663 VIN.n664 6.3005
R2393 VIN.n463 VIN.n664 6.3005
R2394 VIN.n665 VIN.n666 6.3005
R2395 VIN.n461 VIN.n666 6.3005
R2396 VIN.n667 VIN.n668 6.3005
R2397 VIN.n459 VIN.n668 6.3005
R2398 VIN.n669 VIN.n670 6.3005
R2399 VIN.n457 VIN.n670 6.3005
R2400 VIN.n671 VIN.n672 6.3005
R2401 VIN.n455 VIN.n672 6.3005
R2402 VIN.n673 VIN.n674 6.3005
R2403 VIN.n453 VIN.n674 6.3005
R2404 VIN.n675 VIN.n676 6.3005
R2405 VIN.n451 VIN.n676 6.3005
R2406 VIN.n677 VIN.n678 6.3005
R2407 VIN.n449 VIN.n678 6.3005
R2408 VIN.n679 VIN.n680 6.3005
R2409 VIN.n447 VIN.n680 6.3005
R2410 VIN.n681 VIN.n682 6.3005
R2411 VIN.n445 VIN.n682 6.3005
R2412 VIN.n683 VIN.n684 6.3005
R2413 VIN.n443 VIN.n684 6.3005
R2414 VIN.n685 VIN.n686 6.3005
R2415 VIN.n441 VIN.n686 6.3005
R2416 VIN.n687 VIN.n688 6.3005
R2417 VIN.n439 VIN.n688 6.3005
R2418 VIN.n689 VIN.n690 6.3005
R2419 VIN.n691 VIN.n690 6.3005
R2420 VIN.n692 VIN.n690 67.9005
R2421 VIN.n690 VIN.n688 14.0005
R2422 VIN.n688 VIN.n686 14.0005
R2423 VIN.n686 VIN.n684 14.0005
R2424 VIN.n684 VIN.n682 14.0005
R2425 VIN.n682 VIN.n680 14.0005
R2426 VIN.n680 VIN.n678 14.0005
R2427 VIN.n678 VIN.n676 14.0005
R2428 VIN.n676 VIN.n674 14.0005
R2429 VIN.n674 VIN.n672 14.0005
R2430 VIN.n672 VIN.n670 14.0005
R2431 VIN.n670 VIN.n668 14.0005
R2432 VIN.n668 VIN.n666 14.0005
R2433 VIN.n666 VIN.n664 14.0005
R2434 VIN.n664 VIN.n662 14.0005
R2435 VIN.n662 VIN.n660 14.0005
R2436 VIN.n660 VIN.n658 14.0005
R2437 VIN.n658 VIN.n656 14.0005
R2438 VIN.n656 VIN.n654 14.0005
R2439 VIN.n654 VIN.n652 14.0005
R2440 VIN.n652 VIN.n650 14.0005
R2441 VIN.n650 VIN.n648 14.0005
R2442 VIN.n648 VIN.n646 14.0005
R2443 VIN.n646 VIN.n644 14.0005
R2444 VIN.n644 VIN.n642 14.0005
R2445 VIN.n642 VIN.n640 14.0005
R2446 VIN.n640 VIN.n639 14.0005
R2447 VIN.n639 VIN.n637 14.0005
R2448 VIN.n637 VIN.n635 14.0005
R2449 VIN.n635 VIN.n633 14.0005
R2450 VIN.n633 VIN.n631 14.0005
R2451 VIN.n631 VIN.n629 14.0005
R2452 VIN.n629 VIN.n627 14.0005
R2453 VIN.n627 VIN.n625 14.0005
R2454 VIN.n625 VIN.n623 14.0005
R2455 VIN.n623 VIN.n621 14.0005
R2456 VIN.n621 VIN.n619 14.0005
R2457 VIN.n619 VIN.n617 14.0005
R2458 VIN.n617 VIN.n615 14.0005
R2459 VIN.n615 VIN.n613 14.0005
R2460 VIN.n613 VIN.n611 14.0005
R2461 VIN.n611 VIN.n609 14.0005
R2462 VIN.n609 VIN.n607 14.0005
R2463 VIN.n607 VIN.n605 14.0005
R2464 VIN.n605 VIN.n603 14.0005
R2465 VIN.n603 VIN.n601 14.0005
R2466 VIN.n601 VIN.n599 14.0005
R2467 VIN.n599 VIN.n597 14.0005
R2468 VIN.n597 VIN.n595 14.0005
R2469 VIN.n595 VIN.n593 14.0005
R2470 VIN.n593 VIN.n591 14.0005
R2471 VIN.n591 VIN.n434 67.9005
R2472 VIN.n439 VIN.n691 0.1445
R2473 VIN.n441 VIN.n439 0.1445
R2474 VIN.n443 VIN.n441 0.1445
R2475 VIN.n445 VIN.n443 0.1445
R2476 VIN.n447 VIN.n445 0.1445
R2477 VIN.n449 VIN.n447 0.1445
R2478 VIN.n451 VIN.n449 0.1445
R2479 VIN.n451 VIN.n453 0.1445
R2480 VIN.n455 VIN.n453 0.1445
R2481 VIN.n457 VIN.n455 0.1445
R2482 VIN.n459 VIN.n457 0.1445
R2483 VIN.n461 VIN.n459 0.1445
R2484 VIN.n461 VIN.n463 0.1445
R2485 VIN.n465 VIN.n463 0.1445
R2486 VIN.n467 VIN.n465 0.1445
R2487 VIN.n469 VIN.n467 0.1445
R2488 VIN.n471 VIN.n469 0.1445
R2489 VIN.n473 VIN.n471 0.1445
R2490 VIN.n475 VIN.n473 0.1445
R2491 VIN.n477 VIN.n475 0.1445
R2492 VIN.n479 VIN.n477 0.1445
R2493 VIN.n479 VIN.n481 0.1445
R2494 VIN.n483 VIN.n481 0.1445
R2495 VIN.n483 VIN.n485 0.1445
R2496 VIN.n485 VIN.n487 0.1445
R2497 VIN.n489 VIN.n487 0.1445
R2498 VIN.n491 VIN.n489 0.1445
R2499 VIN.n493 VIN.n491 0.1445
R2500 VIN.n495 VIN.n493 0.1445
R2501 VIN.n497 VIN.n495 0.1445
R2502 VIN.n499 VIN.n497 0.1445
R2503 VIN.n501 VIN.n499 0.1445
R2504 VIN.n503 VIN.n501 0.1445
R2505 VIN.n505 VIN.n503 0.1445
R2506 VIN.n507 VIN.n505 0.1445
R2507 VIN.n509 VIN.n507 0.1445
R2508 VIN.n509 VIN.n511 0.1445
R2509 VIN.n513 VIN.n511 0.1445
R2510 VIN.n515 VIN.n513 0.1445
R2511 VIN.n517 VIN.n515 0.1445
R2512 VIN.n519 VIN.n517 0.1445
R2513 VIN.n521 VIN.n519 0.1445
R2514 VIN.n523 VIN.n521 0.1445
R2515 VIN.n523 VIN.n525 0.1445
R2516 VIN.n527 VIN.n525 0.1445
R2517 VIN.n527 VIN.n529 0.1445
R2518 VIN.n531 VIN.n529 0.1445
R2519 VIN.n533 VIN.n531 0.1445
R2520 VIN.n535 VIN.n533 0.1445
R2521 VIN.n535 VIN.n436 0.1445
R2522 VIN.n692 VIN.n537 51.9559
R2523 VIN.n689 VIN.n687 131.149
R2524 VIN.n687 VIN.n685 131.149
R2525 VIN.n685 VIN.n683 131.149
R2526 VIN.n683 VIN.n681 131.149
R2527 VIN.n681 VIN.n679 131.149
R2528 VIN.n679 VIN.n677 131.149
R2529 VIN.n677 VIN.n675 131.149
R2530 VIN.n675 VIN.n673 131.149
R2531 VIN.n673 VIN.n671 131.149
R2532 VIN.n671 VIN.n669 131.149
R2533 VIN.n669 VIN.n667 131.149
R2534 VIN.n667 VIN.n665 131.149
R2535 VIN.n665 VIN.n663 131.149
R2536 VIN.n663 VIN.n661 131.149
R2537 VIN.n661 VIN.n659 131.149
R2538 VIN.n659 VIN.n657 131.149
R2539 VIN.n657 VIN.n655 131.149
R2540 VIN.n655 VIN.n653 131.149
R2541 VIN.n653 VIN.n651 131.149
R2542 VIN.n651 VIN.n649 131.149
R2543 VIN.n649 VIN.n647 131.149
R2544 VIN.n647 VIN.n645 131.149
R2545 VIN.n645 VIN.n643 131.149
R2546 VIN.n643 VIN.n641 131.149
R2547 VIN.n641 VIN.t268 131.149
R2548 VIN.t268 VIN.n638 131.149
R2549 VIN.n638 VIN.n636 131.149
R2550 VIN.n636 VIN.n634 131.149
R2551 VIN.n634 VIN.n632 131.149
R2552 VIN.n632 VIN.n630 131.149
R2553 VIN.n630 VIN.n628 131.149
R2554 VIN.n628 VIN.n626 131.149
R2555 VIN.n626 VIN.n624 131.149
R2556 VIN.n624 VIN.n622 131.149
R2557 VIN.n622 VIN.n620 131.149
R2558 VIN.n620 VIN.n618 131.149
R2559 VIN.n618 VIN.n616 131.149
R2560 VIN.n616 VIN.n614 131.149
R2561 VIN.n614 VIN.n612 131.149
R2562 VIN.n612 VIN.n610 131.149
R2563 VIN.n610 VIN.n608 131.149
R2564 VIN.n608 VIN.n606 131.149
R2565 VIN.n606 VIN.n604 131.149
R2566 VIN.n604 VIN.n602 131.149
R2567 VIN.n602 VIN.n600 131.149
R2568 VIN.n600 VIN.n598 131.149
R2569 VIN.n598 VIN.n596 131.149
R2570 VIN.n596 VIN.n594 131.149
R2571 VIN.n594 VIN.n592 131.149
R2572 VIN.n592 VIN.n590 131.149
R2573 VIN.n433 VIN.n590 4.82156
R2574 VIN.n589 VIN.n335 0.1445
R2575 VIN.n337 VIN.n335 0.1445
R2576 VIN.n337 VIN.n339 0.1445
R2577 VIN.n339 VIN.n341 0.1445
R2578 VIN.n343 VIN.n341 0.1445
R2579 VIN.n345 VIN.n343 0.1445
R2580 VIN.n347 VIN.n345 0.1445
R2581 VIN.n349 VIN.n347 0.1445
R2582 VIN.n351 VIN.n349 0.1445
R2583 VIN.n353 VIN.n351 0.1445
R2584 VIN.n353 VIN.n355 0.1445
R2585 VIN.n357 VIN.n355 0.1445
R2586 VIN.n357 VIN.n359 0.1445
R2587 VIN.n361 VIN.n359 0.1445
R2588 VIN.n363 VIN.n361 0.1445
R2589 VIN.n365 VIN.n363 0.1445
R2590 VIN.n365 VIN.n367 0.1445
R2591 VIN.n369 VIN.n367 0.1445
R2592 VIN.n371 VIN.n369 0.1445
R2593 VIN.n373 VIN.n371 0.1445
R2594 VIN.n375 VIN.n373 0.1445
R2595 VIN.n377 VIN.n375 0.1445
R2596 VIN.n379 VIN.n377 0.1445
R2597 VIN.n381 VIN.n379 0.1445
R2598 VIN.n383 VIN.n381 0.1445
R2599 VIN.n385 VIN.n383 0.1445
R2600 VIN.n387 VIN.n385 0.1445
R2601 VIN.n389 VIN.n387 0.1445
R2602 VIN.n391 VIN.n389 0.1445
R2603 VIN.n393 VIN.n391 0.1445
R2604 VIN.n395 VIN.n393 0.1445
R2605 VIN.n397 VIN.n395 0.1445
R2606 VIN.n399 VIN.n397 0.1445
R2607 VIN.n401 VIN.n399 0.1445
R2608 VIN.n403 VIN.n401 0.1445
R2609 VIN.n403 VIN.n405 0.1445
R2610 VIN.n405 VIN.n407 0.1445
R2611 VIN.n407 VIN.n409 0.1445
R2612 VIN.n409 VIN.n411 0.1445
R2613 VIN.n411 VIN.n413 0.1445
R2614 VIN.n413 VIN.n415 0.1445
R2615 VIN.n415 VIN.n417 0.1445
R2616 VIN.n417 VIN.n419 0.1445
R2617 VIN.n419 VIN.n421 0.1445
R2618 VIN.n421 VIN.n423 0.1445
R2619 VIN.n423 VIN.n425 0.1445
R2620 VIN.n425 VIN.n427 0.1445
R2621 VIN.n427 VIN.n429 0.1445
R2622 VIN.n429 VIN.n431 0.1445
R2623 VIN.n431 VIN.n332 0.1445
R2624 VIN.n331 VIN.n330 2.2505
R2625 VIN.n0 VIN.t269 28.9423
R2626 VIN.n1 VIN.n0 1.7915
R2627 VIN.n3 VIN.n1 2.00165
R2628 VIN.n330 VIN.n3 3.66575
R2629 VIN.n330 VIN.n328 1.3937
R2630 VIN.n328 VIN.n326 0.80825
R2631 VIN.n326 VIN.n325 13.1874
R2632 VIN.n328 VIN.n329 10.4897
R2633 VIN.n329 VIN.t174 8.73962
R2634 VIN.n329 VIN.t250 6.07202
R2635 VIN.n326 VIN.n327 9.97866
R2636 VIN.n327 VIN.t275 6.65737
R2637 VIN.n327 VIN.t25 7.21717
R2638 VIN.n5 VIN.n4 4.5005
R2639 VIN.n6 VIN.n231 4.5005
R2640 VIN.n7 VIN.n8 4.5005
R2641 VIN.n10 VIN.n9 4.5005
R2642 VIN.n12 VIN.n11 4.5005
R2643 VIN.n14 VIN.n13 4.5005
R2644 VIN.n16 VIN.n15 4.5005
R2645 VIN.n18 VIN.n17 4.5005
R2646 VIN.n19 VIN.n20 4.5005
R2647 VIN.n21 VIN.n22 4.5005
R2648 VIN.n23 VIN.n24 4.5005
R2649 VIN.n25 VIN.n26 4.5005
R2650 VIN.n27 VIN.n28 4.5005
R2651 VIN.n29 VIN.n30 4.5005
R2652 VIN.n32 VIN.n31 4.5005
R2653 VIN.n33 VIN.n34 4.5005
R2654 VIN.n35 VIN.n36 4.5005
R2655 VIN.n37 VIN.n38 4.5005
R2656 VIN.n40 VIN.n39 4.5005
R2657 VIN.n42 VIN.n41 4.5005
R2658 VIN.n43 VIN.n44 4.5005
R2659 VIN.n45 VIN.n46 4.5005
R2660 VIN.n47 VIN.n48 4.5005
R2661 VIN.n50 VIN.n49 4.5005
R2662 VIN.n52 VIN.n51 4.5005
R2663 VIN.n54 VIN.n53 4.5005
R2664 VIN.n55 VIN.n56 4.5005
R2665 VIN.n57 VIN.n58 4.5005
R2666 VIN.n59 VIN.n60 4.5005
R2667 VIN.n62 VIN.n61 4.5005
R2668 VIN.n63 VIN.n64 4.5005
R2669 VIN.n65 VIN.n66 4.5005
R2670 VIN.n67 VIN.n68 4.5005
R2671 VIN.n69 VIN.n70 4.5005
R2672 VIN.n72 VIN.n71 4.5005
R2673 VIN.n73 VIN.n74 4.5005
R2674 VIN.n75 VIN.n76 4.5005
R2675 VIN.n78 VIN.n77 4.5005
R2676 VIN.n80 VIN.n79 4.5005
R2677 VIN.n81 VIN.n82 4.5005
R2678 VIN.n83 VIN.n84 4.5005
R2679 VIN.n85 VIN.n86 4.5005
R2680 VIN.n87 VIN.n88 4.5005
R2681 VIN.n89 VIN.n90 4.5005
R2682 VIN.n92 VIN.n91 4.5005
R2683 VIN.n8 VIN.n6 0.1445
R2684 VIN.n10 VIN.n8 0.1445
R2685 VIN.n12 VIN.n10 0.1445
R2686 VIN.n14 VIN.n12 0.1445
R2687 VIN.n16 VIN.n14 0.1445
R2688 VIN.n18 VIN.n16 0.1445
R2689 VIN.n20 VIN.n18 0.1445
R2690 VIN.n22 VIN.n20 0.1445
R2691 VIN.n24 VIN.n22 0.1445
R2692 VIN.n26 VIN.n24 0.1445
R2693 VIN.n28 VIN.n26 0.1445
R2694 VIN.n30 VIN.n28 0.1445
R2695 VIN.n32 VIN.n30 0.1445
R2696 VIN.n34 VIN.n32 0.1445
R2697 VIN.n36 VIN.n34 0.1445
R2698 VIN.n38 VIN.n36 0.1445
R2699 VIN.n40 VIN.n38 0.1445
R2700 VIN.n42 VIN.n40 0.1445
R2701 VIN.n44 VIN.n42 0.1445
R2702 VIN.n46 VIN.n44 0.1445
R2703 VIN.n48 VIN.n46 0.1445
R2704 VIN.n50 VIN.n48 0.1445
R2705 VIN.n52 VIN.n50 0.1445
R2706 VIN.n54 VIN.n52 0.1445
R2707 VIN.n56 VIN.n54 0.1445
R2708 VIN.n58 VIN.n56 0.1445
R2709 VIN.n60 VIN.n58 0.1445
R2710 VIN.n62 VIN.n60 0.1445
R2711 VIN.n64 VIN.n62 0.1445
R2712 VIN.n66 VIN.n64 0.1445
R2713 VIN.n68 VIN.n66 0.1445
R2714 VIN.n70 VIN.n68 0.1445
R2715 VIN.n72 VIN.n70 0.1445
R2716 VIN.n74 VIN.n72 0.1445
R2717 VIN.n76 VIN.n74 0.1445
R2718 VIN.n78 VIN.n76 0.1445
R2719 VIN.n80 VIN.n78 0.1445
R2720 VIN.n82 VIN.n80 0.1445
R2721 VIN.n84 VIN.n82 0.1445
R2722 VIN.n86 VIN.n84 0.1445
R2723 VIN.n88 VIN.n86 0.1445
R2724 VIN.n90 VIN.n88 0.1445
R2725 VIN.n92 VIN.n90 0.1445
R2726 VIN.n5 VIN.n92 0.1445
R2727 VIN.n325 VIN.n5 0.1436
R2728 VIN.n95 VIN.n94 0.0697308
R2729 VIN.n325 VIN.n95 8.90506
R2730 VIN.n95 VIN.n184 9.04816
R2731 VIN.n97 VIN.n96 4.5005
R2732 VIN.n99 VIN.n98 4.5005
R2733 VIN.n100 VIN.n101 4.5005
R2734 VIN.n102 VIN.n103 4.5005
R2735 VIN.n104 VIN.n105 4.5005
R2736 VIN.n106 VIN.n107 4.5005
R2737 VIN.n108 VIN.n109 4.5005
R2738 VIN.n110 VIN.n111 4.5005
R2739 VIN.n112 VIN.n113 4.5005
R2740 VIN.n114 VIN.n115 4.5005
R2741 VIN.n116 VIN.n117 4.5005
R2742 VIN.n118 VIN.n119 4.5005
R2743 VIN.n120 VIN.n121 4.5005
R2744 VIN.n122 VIN.n123 4.5005
R2745 VIN.n124 VIN.n125 4.5005
R2746 VIN.n126 VIN.n127 4.5005
R2747 VIN.n128 VIN.n129 4.5005
R2748 VIN.n130 VIN.n131 4.5005
R2749 VIN.n132 VIN.n133 4.5005
R2750 VIN.n134 VIN.n135 4.5005
R2751 VIN.n137 VIN.n136 4.5005
R2752 VIN.n138 VIN.n139 4.5005
R2753 VIN.n141 VIN.n140 4.5005
R2754 VIN.n143 VIN.n142 4.5005
R2755 VIN.n145 VIN.n144 4.5005
R2756 VIN.n146 VIN.n147 4.5005
R2757 VIN.n149 VIN.n148 4.5005
R2758 VIN.n150 VIN.n151 4.5005
R2759 VIN.n152 VIN.n153 4.5005
R2760 VIN.n155 VIN.n154 4.5005
R2761 VIN.n156 VIN.n157 4.5005
R2762 VIN.n159 VIN.n158 4.5005
R2763 VIN.n160 VIN.n161 4.5005
R2764 VIN.n163 VIN.n162 4.5005
R2765 VIN.n165 VIN.n164 4.5005
R2766 VIN.n166 VIN.n167 4.5005
R2767 VIN.n168 VIN.n169 4.5005
R2768 VIN.n170 VIN.n171 4.5005
R2769 VIN.n172 VIN.n173 4.5005
R2770 VIN.n174 VIN.n175 4.5005
R2771 VIN.n176 VIN.n177 4.5005
R2772 VIN.n179 VIN.n178 4.5005
R2773 VIN.n180 VIN.n181 4.5005
R2774 VIN.n183 VIN.n182 4.5005
R2775 VIN.n184 VIN.n322 4.5005
R2776 VIN.n99 VIN.n97 0.1445
R2777 VIN.n101 VIN.n99 0.1445
R2778 VIN.n103 VIN.n101 0.1445
R2779 VIN.n105 VIN.n103 0.1445
R2780 VIN.n107 VIN.n105 0.1445
R2781 VIN.n109 VIN.n107 0.1445
R2782 VIN.n111 VIN.n109 0.1445
R2783 VIN.n113 VIN.n111 0.1445
R2784 VIN.n115 VIN.n113 0.1445
R2785 VIN.n117 VIN.n115 0.1445
R2786 VIN.n119 VIN.n117 0.1445
R2787 VIN.n121 VIN.n119 0.1445
R2788 VIN.n123 VIN.n121 0.1445
R2789 VIN.n125 VIN.n123 0.1445
R2790 VIN.n127 VIN.n125 0.1445
R2791 VIN.n129 VIN.n127 0.1445
R2792 VIN.n131 VIN.n129 0.1445
R2793 VIN.n133 VIN.n131 0.1445
R2794 VIN.n135 VIN.n133 0.1445
R2795 VIN.n137 VIN.n135 0.1445
R2796 VIN.n139 VIN.n137 0.1445
R2797 VIN.n141 VIN.n139 0.1445
R2798 VIN.n143 VIN.n141 0.1445
R2799 VIN.n145 VIN.n143 0.1445
R2800 VIN.n147 VIN.n145 0.1445
R2801 VIN.n149 VIN.n147 0.1445
R2802 VIN.n151 VIN.n149 0.1445
R2803 VIN.n153 VIN.n151 0.1445
R2804 VIN.n155 VIN.n153 0.1445
R2805 VIN.n157 VIN.n155 0.1445
R2806 VIN.n159 VIN.n157 0.1445
R2807 VIN.n161 VIN.n159 0.1445
R2808 VIN.n163 VIN.n161 0.1445
R2809 VIN.n165 VIN.n163 0.1445
R2810 VIN.n167 VIN.n165 0.1445
R2811 VIN.n169 VIN.n167 0.1445
R2812 VIN.n171 VIN.n169 0.1445
R2813 VIN.n173 VIN.n171 0.1445
R2814 VIN.n175 VIN.n173 0.1445
R2815 VIN.n177 VIN.n175 0.1445
R2816 VIN.n179 VIN.n177 0.1445
R2817 VIN.n181 VIN.n179 0.1445
R2818 VIN.n183 VIN.n181 0.1445
R2819 VIN.n184 VIN.n183 0.1445
R2820 VIN.n324 VIN.n323 0.0697308
R2821 VIN.n324 VIN.n97 9.04816
R2822 VIN.n6 VIN.n324 9.04816
R2823 VIN.n186 VIN.n93 5.82142
R2824 VIN.n4 VIN.n186 6.3005
R2825 VIN.n187 VIN.n318 6.3005
R2826 VIN.n91 VIN.n187 6.3005
R2827 VIN.n188 VIN.n316 6.3005
R2828 VIN.n89 VIN.n188 6.3005
R2829 VIN.n189 VIN.n314 6.3005
R2830 VIN.n87 VIN.n189 6.3005
R2831 VIN.n190 VIN.n312 6.3005
R2832 VIN.n85 VIN.n190 6.3005
R2833 VIN.n191 VIN.n310 6.3005
R2834 VIN.n83 VIN.n191 6.3005
R2835 VIN.n192 VIN.n308 6.3005
R2836 VIN.n81 VIN.n192 6.3005
R2837 VIN.n193 VIN.n306 6.3005
R2838 VIN.n79 VIN.n193 6.3005
R2839 VIN.n194 VIN.n304 6.3005
R2840 VIN.n77 VIN.n194 6.3005
R2841 VIN.n195 VIN.n302 6.3005
R2842 VIN.n75 VIN.n195 6.3005
R2843 VIN.n196 VIN.n300 6.3005
R2844 VIN.n73 VIN.n196 6.3005
R2845 VIN.n197 VIN.n298 6.3005
R2846 VIN.n71 VIN.n197 6.3005
R2847 VIN.n198 VIN.n296 6.3005
R2848 VIN.n69 VIN.n198 6.3005
R2849 VIN.n199 VIN.n294 6.3005
R2850 VIN.n67 VIN.n199 6.3005
R2851 VIN.n200 VIN.n292 6.3005
R2852 VIN.n65 VIN.n200 6.3005
R2853 VIN.n201 VIN.n290 6.3005
R2854 VIN.n63 VIN.n201 6.3005
R2855 VIN.n202 VIN.n288 6.3005
R2856 VIN.n61 VIN.n202 6.3005
R2857 VIN.n203 VIN.n286 6.3005
R2858 VIN.n59 VIN.n203 6.3005
R2859 VIN.n204 VIN.n284 6.3005
R2860 VIN.n57 VIN.n204 6.3005
R2861 VIN.n205 VIN.n282 6.3005
R2862 VIN.n55 VIN.n205 6.3005
R2863 VIN.n206 VIN.n280 6.3005
R2864 VIN.n53 VIN.n206 6.3005
R2865 VIN.n207 VIN.n278 6.3005
R2866 VIN.n51 VIN.n207 6.3005
R2867 VIN.n208 VIN.n276 6.3005
R2868 VIN.n49 VIN.n208 6.3005
R2869 VIN.n209 VIN.n274 6.3005
R2870 VIN.n47 VIN.n209 6.3005
R2871 VIN.n210 VIN.n272 6.3005
R2872 VIN.n45 VIN.n210 6.3005
R2873 VIN.n211 VIN.n270 6.3005
R2874 VIN.n43 VIN.n211 6.3005
R2875 VIN.n212 VIN.n268 6.3005
R2876 VIN.n41 VIN.n212 6.3005
R2877 VIN.n213 VIN.n266 6.3005
R2878 VIN.n39 VIN.n213 6.3005
R2879 VIN.n214 VIN.n264 6.3005
R2880 VIN.n37 VIN.n214 6.3005
R2881 VIN.n215 VIN.n262 6.3005
R2882 VIN.n35 VIN.n215 6.3005
R2883 VIN.n216 VIN.n260 6.3005
R2884 VIN.n33 VIN.n216 6.3005
R2885 VIN.n217 VIN.n258 6.3005
R2886 VIN.n31 VIN.n217 6.3005
R2887 VIN.n218 VIN.n256 6.3005
R2888 VIN.n29 VIN.n218 6.3005
R2889 VIN.n219 VIN.n254 6.3005
R2890 VIN.n27 VIN.n219 6.3005
R2891 VIN.n220 VIN.n252 6.3005
R2892 VIN.n25 VIN.n220 6.3005
R2893 VIN.n221 VIN.n250 6.3005
R2894 VIN.n23 VIN.n221 6.3005
R2895 VIN.n222 VIN.n248 6.3005
R2896 VIN.n21 VIN.n222 6.3005
R2897 VIN.n223 VIN.n246 6.3005
R2898 VIN.n19 VIN.n223 6.3005
R2899 VIN.n224 VIN.n244 6.3005
R2900 VIN.n17 VIN.n224 6.3005
R2901 VIN.n225 VIN.n242 6.3005
R2902 VIN.n15 VIN.n225 6.3005
R2903 VIN.n226 VIN.n240 6.3005
R2904 VIN.n13 VIN.n226 6.3005
R2905 VIN.n227 VIN.n238 6.3005
R2906 VIN.n11 VIN.n227 6.3005
R2907 VIN.n228 VIN.n236 6.3005
R2908 VIN.n9 VIN.n228 6.3005
R2909 VIN.n229 VIN.n234 6.3005
R2910 VIN.n7 VIN.n229 6.3005
R2911 VIN.n185 VIN.n232 0.390266
R2912 VIN.n231 VIN.n230 6.3005
R2913 VIN.n230 VIN.n185 5.82142
R2914 VIN.n230 VIN.n229 14.0005
R2915 VIN.n229 VIN.n228 14.0005
R2916 VIN.n228 VIN.n227 14.0005
R2917 VIN.n227 VIN.n226 14.0005
R2918 VIN.n226 VIN.n225 14.0005
R2919 VIN.n225 VIN.n224 14.0005
R2920 VIN.n224 VIN.n223 14.0005
R2921 VIN.n223 VIN.n222 14.0005
R2922 VIN.n222 VIN.n221 14.0005
R2923 VIN.n221 VIN.n220 14.0005
R2924 VIN.n220 VIN.n219 14.0005
R2925 VIN.n219 VIN.n218 14.0005
R2926 VIN.n218 VIN.n217 14.0005
R2927 VIN.n217 VIN.n216 14.0005
R2928 VIN.n216 VIN.n215 14.0005
R2929 VIN.n215 VIN.n214 14.0005
R2930 VIN.n214 VIN.n213 14.0005
R2931 VIN.n213 VIN.n212 14.0005
R2932 VIN.n212 VIN.n211 14.0005
R2933 VIN.n211 VIN.n210 14.0005
R2934 VIN.n210 VIN.n209 14.0005
R2935 VIN.n209 VIN.n208 14.0005
R2936 VIN.n208 VIN.n207 14.0005
R2937 VIN.n207 VIN.n206 14.0005
R2938 VIN.n206 VIN.n205 14.0005
R2939 VIN.n205 VIN.n204 14.0005
R2940 VIN.n204 VIN.n203 14.0005
R2941 VIN.n203 VIN.n202 14.0005
R2942 VIN.n202 VIN.n201 14.0005
R2943 VIN.n201 VIN.n200 14.0005
R2944 VIN.n200 VIN.n199 14.0005
R2945 VIN.n199 VIN.n198 14.0005
R2946 VIN.n198 VIN.n197 14.0005
R2947 VIN.n197 VIN.n196 14.0005
R2948 VIN.n196 VIN.n195 14.0005
R2949 VIN.n195 VIN.n194 14.0005
R2950 VIN.n194 VIN.n193 14.0005
R2951 VIN.n193 VIN.n192 14.0005
R2952 VIN.n192 VIN.n191 14.0005
R2953 VIN.n191 VIN.n190 14.0005
R2954 VIN.n190 VIN.n189 14.0005
R2955 VIN.n189 VIN.n188 14.0005
R2956 VIN.n188 VIN.n187 14.0005
R2957 VIN.n187 VIN.n186 14.0005
R2958 VIN.n93 VIN.n94 25.087
R2959 VIN.n232 VIN.n233 6.3005
R2960 VIN.n233 VIN.n96 6.3005
R2961 VIN.n234 VIN.n235 6.3005
R2962 VIN.n235 VIN.n98 6.3005
R2963 VIN.n236 VIN.n237 6.3005
R2964 VIN.n237 VIN.n100 6.3005
R2965 VIN.n238 VIN.n239 6.3005
R2966 VIN.n239 VIN.n102 6.3005
R2967 VIN.n240 VIN.n241 6.3005
R2968 VIN.n241 VIN.n104 6.3005
R2969 VIN.n242 VIN.n243 6.3005
R2970 VIN.n243 VIN.n106 6.3005
R2971 VIN.n244 VIN.n245 6.3005
R2972 VIN.n245 VIN.n108 6.3005
R2973 VIN.n246 VIN.n247 6.3005
R2974 VIN.n247 VIN.n110 6.3005
R2975 VIN.n248 VIN.n249 6.3005
R2976 VIN.n249 VIN.n112 6.3005
R2977 VIN.n250 VIN.n251 6.3005
R2978 VIN.n251 VIN.n114 6.3005
R2979 VIN.n252 VIN.n253 6.3005
R2980 VIN.n253 VIN.n116 6.3005
R2981 VIN.n254 VIN.n255 6.3005
R2982 VIN.n255 VIN.n118 6.3005
R2983 VIN.n256 VIN.n257 6.3005
R2984 VIN.n257 VIN.n120 6.3005
R2985 VIN.n258 VIN.n259 6.3005
R2986 VIN.n259 VIN.n122 6.3005
R2987 VIN.n260 VIN.n261 6.3005
R2988 VIN.n261 VIN.n124 6.3005
R2989 VIN.n262 VIN.n263 6.3005
R2990 VIN.n263 VIN.n126 6.3005
R2991 VIN.n264 VIN.n265 6.3005
R2992 VIN.n265 VIN.n128 6.3005
R2993 VIN.n266 VIN.n267 6.3005
R2994 VIN.n267 VIN.n130 6.3005
R2995 VIN.n268 VIN.n269 6.3005
R2996 VIN.n269 VIN.n132 6.3005
R2997 VIN.n270 VIN.n271 6.3005
R2998 VIN.n271 VIN.n134 6.3005
R2999 VIN.n272 VIN.n273 6.3005
R3000 VIN.n273 VIN.n136 6.3005
R3001 VIN.n274 VIN.n275 6.3005
R3002 VIN.n275 VIN.n138 6.3005
R3003 VIN.n276 VIN.n277 6.3005
R3004 VIN.n277 VIN.n140 6.3005
R3005 VIN.n278 VIN.n279 6.3005
R3006 VIN.n279 VIN.n142 6.3005
R3007 VIN.n280 VIN.n281 6.3005
R3008 VIN.n281 VIN.n144 6.3005
R3009 VIN.n282 VIN.n283 6.3005
R3010 VIN.n283 VIN.n146 6.3005
R3011 VIN.n284 VIN.n285 6.3005
R3012 VIN.n285 VIN.n148 6.3005
R3013 VIN.n286 VIN.n287 6.3005
R3014 VIN.n287 VIN.n150 6.3005
R3015 VIN.n288 VIN.n289 6.3005
R3016 VIN.n289 VIN.n152 6.3005
R3017 VIN.n290 VIN.n291 6.3005
R3018 VIN.n291 VIN.n154 6.3005
R3019 VIN.n292 VIN.n293 6.3005
R3020 VIN.n293 VIN.n156 6.3005
R3021 VIN.n294 VIN.n295 6.3005
R3022 VIN.n295 VIN.n158 6.3005
R3023 VIN.n296 VIN.n297 6.3005
R3024 VIN.n297 VIN.n160 6.3005
R3025 VIN.n298 VIN.n299 6.3005
R3026 VIN.n299 VIN.n162 6.3005
R3027 VIN.n300 VIN.n301 6.3005
R3028 VIN.n301 VIN.n164 6.3005
R3029 VIN.n302 VIN.n303 6.3005
R3030 VIN.n303 VIN.n166 6.3005
R3031 VIN.n304 VIN.n305 6.3005
R3032 VIN.n305 VIN.n168 6.3005
R3033 VIN.n306 VIN.n307 6.3005
R3034 VIN.n307 VIN.n170 6.3005
R3035 VIN.n308 VIN.n309 6.3005
R3036 VIN.n309 VIN.n172 6.3005
R3037 VIN.n310 VIN.n311 6.3005
R3038 VIN.n311 VIN.n174 6.3005
R3039 VIN.n312 VIN.n313 6.3005
R3040 VIN.n313 VIN.n176 6.3005
R3041 VIN.n314 VIN.n315 6.3005
R3042 VIN.n315 VIN.n178 6.3005
R3043 VIN.n316 VIN.n317 6.3005
R3044 VIN.n317 VIN.n180 6.3005
R3045 VIN.n318 VIN.n319 6.3005
R3046 VIN.n319 VIN.n182 6.3005
R3047 VIN.n320 VIN.n321 6.3005
R3048 VIN.n321 VIN.n322 6.3005
R3049 VIN.n323 VIN.n233 406
R3050 VIN.n233 VIN.n235 14.0005
R3051 VIN.n235 VIN.n237 14.0005
R3052 VIN.n237 VIN.n239 14.0005
R3053 VIN.n239 VIN.n241 14.0005
R3054 VIN.n241 VIN.n243 14.0005
R3055 VIN.n243 VIN.n245 14.0005
R3056 VIN.n245 VIN.n247 14.0005
R3057 VIN.n247 VIN.n249 14.0005
R3058 VIN.n249 VIN.n251 14.0005
R3059 VIN.n251 VIN.n253 14.0005
R3060 VIN.n253 VIN.n255 14.0005
R3061 VIN.n255 VIN.n257 14.0005
R3062 VIN.n257 VIN.n259 14.0005
R3063 VIN.n259 VIN.n261 14.0005
R3064 VIN.n261 VIN.n263 14.0005
R3065 VIN.n263 VIN.n265 14.0005
R3066 VIN.n265 VIN.n267 14.0005
R3067 VIN.n267 VIN.n269 14.0005
R3068 VIN.n269 VIN.n271 14.0005
R3069 VIN.n271 VIN.n273 14.0005
R3070 VIN.n273 VIN.n275 14.0005
R3071 VIN.n275 VIN.n277 14.0005
R3072 VIN.n277 VIN.n279 14.0005
R3073 VIN.n279 VIN.n281 14.0005
R3074 VIN.n281 VIN.n283 14.0005
R3075 VIN.n283 VIN.n285 14.0005
R3076 VIN.n285 VIN.n287 14.0005
R3077 VIN.n287 VIN.n289 14.0005
R3078 VIN.n289 VIN.n291 14.0005
R3079 VIN.n291 VIN.n293 14.0005
R3080 VIN.n293 VIN.n295 14.0005
R3081 VIN.n295 VIN.n297 14.0005
R3082 VIN.n297 VIN.n299 14.0005
R3083 VIN.n299 VIN.n301 14.0005
R3084 VIN.n301 VIN.n303 14.0005
R3085 VIN.n303 VIN.n305 14.0005
R3086 VIN.n305 VIN.n307 14.0005
R3087 VIN.n307 VIN.n309 14.0005
R3088 VIN.n309 VIN.n311 14.0005
R3089 VIN.n311 VIN.n313 14.0005
R3090 VIN.n313 VIN.n315 14.0005
R3091 VIN.n315 VIN.n317 14.0005
R3092 VIN.n317 VIN.n319 14.0005
R3093 VIN.n319 VIN.n321 14.0005
R3094 VIN.n321 VIN.n94 406
R3095 VIN.n96 VIN.n98 0.1445
R3096 VIN.n98 VIN.n100 0.1445
R3097 VIN.n102 VIN.n100 0.1445
R3098 VIN.n104 VIN.n102 0.1445
R3099 VIN.n106 VIN.n104 0.1445
R3100 VIN.n108 VIN.n106 0.1445
R3101 VIN.n110 VIN.n108 0.1445
R3102 VIN.n112 VIN.n110 0.1445
R3103 VIN.n114 VIN.n112 0.1445
R3104 VIN.n116 VIN.n114 0.1445
R3105 VIN.n118 VIN.n116 0.1445
R3106 VIN.n120 VIN.n118 0.1445
R3107 VIN.n122 VIN.n120 0.1445
R3108 VIN.n124 VIN.n122 0.1445
R3109 VIN.n126 VIN.n124 0.1445
R3110 VIN.n128 VIN.n126 0.1445
R3111 VIN.n130 VIN.n128 0.1445
R3112 VIN.n132 VIN.n130 0.1445
R3113 VIN.n134 VIN.n132 0.1445
R3114 VIN.n136 VIN.n134 0.1445
R3115 VIN.n136 VIN.n138 0.1445
R3116 VIN.n140 VIN.n138 0.1445
R3117 VIN.n140 VIN.n142 0.1445
R3118 VIN.n142 VIN.n144 0.1445
R3119 VIN.n144 VIN.n146 0.1445
R3120 VIN.n148 VIN.n146 0.1445
R3121 VIN.n148 VIN.n150 0.1445
R3122 VIN.n152 VIN.n150 0.1445
R3123 VIN.n154 VIN.n152 0.1445
R3124 VIN.n154 VIN.n156 0.1445
R3125 VIN.n158 VIN.n156 0.1445
R3126 VIN.n158 VIN.n160 0.1445
R3127 VIN.n162 VIN.n160 0.1445
R3128 VIN.n162 VIN.n164 0.1445
R3129 VIN.n164 VIN.n166 0.1445
R3130 VIN.n168 VIN.n166 0.1445
R3131 VIN.n170 VIN.n168 0.1445
R3132 VIN.n172 VIN.n170 0.1445
R3133 VIN.n174 VIN.n172 0.1445
R3134 VIN.n176 VIN.n174 0.1445
R3135 VIN.n178 VIN.n176 0.1445
R3136 VIN.n178 VIN.n180 0.1445
R3137 VIN.n182 VIN.n180 0.1445
R3138 VIN.n182 VIN.n322 0.1445
R3139 VIN.n323 VIN.n185 25.087
R3140 VIN.n232 VIN.n234 17.6879
R3141 VIN.n234 VIN.n236 17.6879
R3142 VIN.n236 VIN.t2 13.7082
R3143 VIN.n238 VIN.t2 3.98016
R3144 VIN.n238 VIN.n240 17.6879
R3145 VIN.n240 VIN.t28 2.8747
R3146 VIN.t28 VIN.n242 14.8137
R3147 VIN.n242 VIN.t68 9.72856
R3148 VIN.n244 VIN.t68 7.95982
R3149 VIN.n244 VIN.t144 16.5824
R3150 VIN.n246 VIN.t144 1.10596
R3151 VIN.n246 VIN.n248 17.6879
R3152 VIN.n248 VIN.t142 5.7489
R3153 VIN.t142 VIN.n250 11.9395
R3154 VIN.n250 VIN.t18 12.6028
R3155 VIN.n252 VIN.t18 5.08562
R3156 VIN.n252 VIN.n254 17.6879
R3157 VIN.n254 VIN.t30 1.76924
R3158 VIN.t30 VIN.n256 15.9191
R3159 VIN.n256 VIN.t132 8.6231
R3160 VIN.t132 VIN.n258 9.06528
R3161 VIN.n258 VIN.t26 15.477
R3162 VIN.n260 VIN.t26 2.21142
R3163 VIN.n260 VIN.n262 17.6879
R3164 VIN.n262 VIN.t43 4.64344
R3165 VIN.t43 VIN.n264 13.0449
R3166 VIN.n264 VIN.t53 11.4973
R3167 VIN.n266 VIN.t53 6.19108
R3168 VIN.n266 VIN.n268 17.6879
R3169 VIN.n268 VIN.t51 0.663777
R3170 VIN.t51 VIN.n270 17.0246
R3171 VIN.n270 VIN.t4 7.51763
R3172 VIN.t4 VIN.n272 10.1707
R3173 VIN.n272 VIN.t41 14.3715
R3174 VIN.n274 VIN.t41 3.31688
R3175 VIN.n274 VIN.n276 17.6879
R3176 VIN.n276 VIN.t62 3.53798
R3177 VIN.t62 VIN.n278 14.1504
R3178 VIN.n278 VIN.t46 10.3918
R3179 VIN.n280 VIN.t46 7.29654
R3180 VIN.n280 VIN.t57 17.2457
R3181 VIN.n282 VIN.t57 0.442684
R3182 VIN.n282 VIN.n284 17.6879
R3183 VIN.n284 VIN.t11 6.41217
R3184 VIN.t11 VIN.n286 11.2762
R3185 VIN.n286 VIN.t36 13.266
R3186 VIN.n288 VIN.t36 4.42234
R3187 VIN.n288 VIN.n290 17.6879
R3188 VIN.n290 VIN.t6 2.43251
R3189 VIN.t6 VIN.n292 15.2559
R3190 VIN.n292 VIN.t34 9.28637
R3191 VIN.n294 VIN.t34 8.402
R3192 VIN.n294 VIN.t20 16.1402
R3193 VIN.n296 VIN.t20 1.54815
R3194 VIN.n296 VIN.n298 17.6879
R3195 VIN.n298 VIN.t0 5.30671
R3196 VIN.t0 VIN.n300 12.3817
R3197 VIN.n300 VIN.t13 12.1606
R3198 VIN.n302 VIN.t13 5.5278
R3199 VIN.n302 VIN.n304 17.6879
R3200 VIN.n304 VIN.t39 1.32705
R3201 VIN.t39 VIN.n306 16.3613
R3202 VIN.n306 VIN.t22 8.18091
R3203 VIN.t22 VIN.n308 9.50746
R3204 VIN.n308 VIN.t65 15.0348
R3205 VIN.n310 VIN.t65 2.65361
R3206 VIN.n310 VIN.n312 17.6879
R3207 VIN.n312 VIN.t8 4.20125
R3208 VIN.t8 VIN.n314 13.4871
R3209 VIN.n314 VIN.t48 11.0551
R3210 VIN.n316 VIN.t48 6.63327
R3211 VIN.n316 VIN.n318 17.6879
R3212 VIN.n318 VIN.t16 0.221592
R3213 VIN.t16 VIN.n320 17.4668
R3214 VIN.n93 VIN.n320 0.390266
R3215 VIN.n231 VIN.n7 0.1445
R3216 VIN.n9 VIN.n7 0.1445
R3217 VIN.n9 VIN.n11 0.1445
R3218 VIN.n11 VIN.n13 0.1445
R3219 VIN.n13 VIN.n15 0.1445
R3220 VIN.n15 VIN.n17 0.1445
R3221 VIN.n17 VIN.n19 0.1445
R3222 VIN.n21 VIN.n19 0.1445
R3223 VIN.n23 VIN.n21 0.1445
R3224 VIN.n25 VIN.n23 0.1445
R3225 VIN.n27 VIN.n25 0.1445
R3226 VIN.n29 VIN.n27 0.1445
R3227 VIN.n31 VIN.n29 0.1445
R3228 VIN.n31 VIN.n33 0.1445
R3229 VIN.n35 VIN.n33 0.1445
R3230 VIN.n37 VIN.n35 0.1445
R3231 VIN.n39 VIN.n37 0.1445
R3232 VIN.n39 VIN.n41 0.1445
R3233 VIN.n41 VIN.n43 0.1445
R3234 VIN.n45 VIN.n43 0.1445
R3235 VIN.n47 VIN.n45 0.1445
R3236 VIN.n49 VIN.n47 0.1445
R3237 VIN.n49 VIN.n51 0.1445
R3238 VIN.n51 VIN.n53 0.1445
R3239 VIN.n53 VIN.n55 0.1445
R3240 VIN.n57 VIN.n55 0.1445
R3241 VIN.n59 VIN.n57 0.1445
R3242 VIN.n61 VIN.n59 0.1445
R3243 VIN.n61 VIN.n63 0.1445
R3244 VIN.n65 VIN.n63 0.1445
R3245 VIN.n67 VIN.n65 0.1445
R3246 VIN.n69 VIN.n67 0.1445
R3247 VIN.n71 VIN.n69 0.1445
R3248 VIN.n71 VIN.n73 0.1445
R3249 VIN.n75 VIN.n73 0.1445
R3250 VIN.n77 VIN.n75 0.1445
R3251 VIN.n77 VIN.n79 0.1445
R3252 VIN.n79 VIN.n81 0.1445
R3253 VIN.n83 VIN.n81 0.1445
R3254 VIN.n85 VIN.n83 0.1445
R3255 VIN.n87 VIN.n85 0.1445
R3256 VIN.n89 VIN.n87 0.1445
R3257 VIN.n91 VIN.n89 0.1445
R3258 VIN.n91 VIN.n4 0.1445
R3259 VIN.n3 VIN.t172 16.7902
R3260 VIN.n1 VIN.n2 10.7526
R3261 VIN.n2 VIN.t266 6.48962
R3262 VIN.n2 VIN.t264 6.07202
R3263 VIN.n0 VIN.t262 16.8241
R3264 VSS VSS.n837 1.81853
R3265 VSS.n837 VSS.n15 2.525
R3266 VSS.n15 VSS.n497 4.6148
R3267 VSS.n837 VSS.n836 2.2505
R3268 VSS.n16 VSS.n284 10.315
R3269 VSS.n17 VSS.n16 0.82715
R3270 VSS.n18 VSS.n17 0.82715
R3271 VSS.n19 VSS.n18 0.82715
R3272 VSS.n20 VSS.n19 0.82715
R3273 VSS.n836 VSS.n20 0.38705
R3274 VSS.n836 VSS.n24 2.05385
R3275 VSS.n24 VSS.n23 0.8285
R3276 VSS.n23 VSS.n22 0.53555
R3277 VSS.n22 VSS.n21 4.57745
R3278 VSS.n21 VSS.n762 12.7684
R3279 VSS.n24 VSS.n835 9.48839
R3280 VSS.n26 VSS.n25 4.5005
R3281 VSS.n152 VSS.n27 4.5005
R3282 VSS.n28 VSS.n29 4.5005
R3283 VSS.n31 VSS.n30 4.5005
R3284 VSS.n33 VSS.n32 4.5005
R3285 VSS.n35 VSS.n34 4.5005
R3286 VSS.n37 VSS.n36 4.5005
R3287 VSS.n39 VSS.n38 4.5005
R3288 VSS.n40 VSS.n41 4.5005
R3289 VSS.n43 VSS.n42 4.5005
R3290 VSS.n45 VSS.n44 4.5005
R3291 VSS.n47 VSS.n46 4.5005
R3292 VSS.n49 VSS.n48 4.5005
R3293 VSS.n51 VSS.n50 4.5005
R3294 VSS.n53 VSS.n52 4.5005
R3295 VSS.n55 VSS.n54 4.5005
R3296 VSS.n57 VSS.n56 4.5005
R3297 VSS.n59 VSS.n58 4.5005
R3298 VSS.n61 VSS.n60 4.5005
R3299 VSS.n63 VSS.n62 4.5005
R3300 VSS.n65 VSS.n64 4.5005
R3301 VSS.n67 VSS.n66 4.5005
R3302 VSS.n69 VSS.n68 4.5005
R3303 VSS.n71 VSS.n70 4.5005
R3304 VSS.n73 VSS.n72 4.5005
R3305 VSS.n29 VSS.n27 0.1445
R3306 VSS.n31 VSS.n29 0.1445
R3307 VSS.n33 VSS.n31 0.1445
R3308 VSS.n35 VSS.n33 0.1445
R3309 VSS.n37 VSS.n35 0.1445
R3310 VSS.n39 VSS.n37 0.1445
R3311 VSS.n41 VSS.n39 0.1445
R3312 VSS.n43 VSS.n41 0.1445
R3313 VSS.n45 VSS.n43 0.1445
R3314 VSS.n47 VSS.n45 0.1445
R3315 VSS.n49 VSS.n47 0.1445
R3316 VSS.n51 VSS.n49 0.1445
R3317 VSS.n53 VSS.n51 0.1445
R3318 VSS.n55 VSS.n53 0.1445
R3319 VSS.n57 VSS.n55 0.1445
R3320 VSS.n59 VSS.n57 0.1445
R3321 VSS.n61 VSS.n59 0.1445
R3322 VSS.n63 VSS.n61 0.1445
R3323 VSS.n65 VSS.n63 0.1445
R3324 VSS.n67 VSS.n65 0.1445
R3325 VSS.n69 VSS.n67 0.1445
R3326 VSS.n71 VSS.n69 0.1445
R3327 VSS.n73 VSS.n71 0.1445
R3328 VSS.n26 VSS.n73 0.1445
R3329 VSS.n835 VSS.n26 0.1274
R3330 VSS.n835 VSS.n832 5.19346
R3331 VSS.n834 VSS.n833 0.113978
R3332 VSS.n832 VSS.n834 0.229413
R3333 VSS.n833 VSS.t62 2.6861
R3334 VSS.n834 VSS.t63 2.57262
R3335 VSS.n833 VSS.t60 30.2232
R3336 VSS.n75 VSS.n74 0.2085
R3337 VSS.n76 VSS.n75 0.2085
R3338 VSS.n832 VSS.n76 0.576696
R3339 VSS.n76 VSS.n78 5.98656
R3340 VSS.n78 VSS.n77 4.5005
R3341 VSS.n79 VSS.n826 4.5005
R3342 VSS.n81 VSS.n80 4.5005
R3343 VSS.n83 VSS.n82 4.5005
R3344 VSS.n85 VSS.n84 4.5005
R3345 VSS.n87 VSS.n86 4.5005
R3346 VSS.n89 VSS.n88 4.5005
R3347 VSS.n91 VSS.n90 4.5005
R3348 VSS.n93 VSS.n92 4.5005
R3349 VSS.n95 VSS.n94 4.5005
R3350 VSS.n97 VSS.n96 4.5005
R3351 VSS.n99 VSS.n98 4.5005
R3352 VSS.n101 VSS.n100 4.5005
R3353 VSS.n103 VSS.n102 4.5005
R3354 VSS.n104 VSS.n105 4.5005
R3355 VSS.n106 VSS.n107 4.5005
R3356 VSS.n108 VSS.n109 4.5005
R3357 VSS.n110 VSS.n111 4.5005
R3358 VSS.n112 VSS.n113 4.5005
R3359 VSS.n114 VSS.n115 4.5005
R3360 VSS.n116 VSS.n117 4.5005
R3361 VSS.n118 VSS.n119 4.5005
R3362 VSS.n120 VSS.n121 4.5005
R3363 VSS.n122 VSS.n123 4.5005
R3364 VSS.n124 VSS.n125 4.5005
R3365 VSS.n81 VSS.n79 0.1445
R3366 VSS.n83 VSS.n81 0.1445
R3367 VSS.n85 VSS.n83 0.1445
R3368 VSS.n87 VSS.n85 0.1445
R3369 VSS.n89 VSS.n87 0.1445
R3370 VSS.n91 VSS.n89 0.1445
R3371 VSS.n93 VSS.n91 0.1445
R3372 VSS.n95 VSS.n93 0.1445
R3373 VSS.n97 VSS.n95 0.1445
R3374 VSS.n99 VSS.n97 0.1445
R3375 VSS.n101 VSS.n99 0.1445
R3376 VSS.n103 VSS.n101 0.1445
R3377 VSS.n105 VSS.n103 0.1445
R3378 VSS.n107 VSS.n105 0.1445
R3379 VSS.n109 VSS.n107 0.1445
R3380 VSS.n111 VSS.n109 0.1445
R3381 VSS.n113 VSS.n111 0.1445
R3382 VSS.n115 VSS.n113 0.1445
R3383 VSS.n117 VSS.n115 0.1445
R3384 VSS.n119 VSS.n117 0.1445
R3385 VSS.n121 VSS.n119 0.1445
R3386 VSS.n123 VSS.n121 0.1445
R3387 VSS.n125 VSS.n123 0.1445
R3388 VSS.n78 VSS.n125 0.1445
R3389 VSS.n827 VSS.n126 0.2085
R3390 VSS.n828 VSS.n827 0.2085
R3391 VSS.n829 VSS.n828 0.576696
R3392 VSS.n828 VSS.n79 5.98656
R3393 VSS.n829 VSS.n831 0.229413
R3394 VSS.n831 VSS.n830 0.113978
R3395 VSS.n831 VSS.t58 2.57262
R3396 VSS.n830 VSS.t59 2.6861
R3397 VSS.n830 VSS.t56 30.2232
R3398 VSS.n27 VSS.n829 5.32036
R3399 VSS.n127 VSS.n153 5.2005
R3400 VSS.n25 VSS.n127 5.2005
R3401 VSS.n128 VSS.n155 5.2005
R3402 VSS.n72 VSS.n128 5.2005
R3403 VSS.n129 VSS.n157 5.2005
R3404 VSS.n70 VSS.n129 5.2005
R3405 VSS.n130 VSS.n159 5.2005
R3406 VSS.n68 VSS.n130 5.2005
R3407 VSS.n131 VSS.n161 5.2005
R3408 VSS.n66 VSS.n131 5.2005
R3409 VSS.n132 VSS.n163 5.2005
R3410 VSS.n64 VSS.n132 5.2005
R3411 VSS.n133 VSS.n165 5.2005
R3412 VSS.n62 VSS.n133 5.2005
R3413 VSS.n134 VSS.n167 5.2005
R3414 VSS.n60 VSS.n134 5.2005
R3415 VSS.n135 VSS.n169 5.2005
R3416 VSS.n58 VSS.n135 5.2005
R3417 VSS.n136 VSS.n171 5.2005
R3418 VSS.n56 VSS.n136 5.2005
R3419 VSS.n137 VSS.n173 5.2005
R3420 VSS.n54 VSS.n137 5.2005
R3421 VSS.n138 VSS.n175 5.2005
R3422 VSS.n52 VSS.n138 5.2005
R3423 VSS.n139 VSS.n177 5.2005
R3424 VSS.n50 VSS.n139 5.2005
R3425 VSS.n140 VSS.n179 5.2005
R3426 VSS.n48 VSS.n140 5.2005
R3427 VSS.n141 VSS.n181 5.2005
R3428 VSS.n46 VSS.n141 5.2005
R3429 VSS.n142 VSS.n183 5.2005
R3430 VSS.n44 VSS.n142 5.2005
R3431 VSS.n143 VSS.n185 5.2005
R3432 VSS.n42 VSS.n143 5.2005
R3433 VSS.n144 VSS.n187 5.2005
R3434 VSS.n40 VSS.n144 5.2005
R3435 VSS.n145 VSS.n189 5.2005
R3436 VSS.n38 VSS.n145 5.2005
R3437 VSS.n146 VSS.n191 5.2005
R3438 VSS.n36 VSS.n146 5.2005
R3439 VSS.n147 VSS.n193 5.2005
R3440 VSS.n34 VSS.n147 5.2005
R3441 VSS.n148 VSS.n195 5.2005
R3442 VSS.n32 VSS.n148 5.2005
R3443 VSS.n149 VSS.n197 5.2005
R3444 VSS.n30 VSS.n149 5.2005
R3445 VSS.n150 VSS.n199 5.2005
R3446 VSS.n28 VSS.n150 5.2005
R3447 VSS.n151 VSS.n201 5.2005
R3448 VSS.n152 VSS.n151 5.2005
R3449 VSS.n827 VSS.n151 146.708
R3450 VSS.n151 VSS.n150 15.5561
R3451 VSS.n150 VSS.n149 15.5561
R3452 VSS.n149 VSS.n148 15.5561
R3453 VSS.n148 VSS.n147 15.5561
R3454 VSS.n147 VSS.n146 15.5561
R3455 VSS.n146 VSS.n145 15.5561
R3456 VSS.n145 VSS.n144 15.5561
R3457 VSS.n144 VSS.n143 15.5561
R3458 VSS.n143 VSS.n142 15.5561
R3459 VSS.n142 VSS.n141 15.5561
R3460 VSS.n141 VSS.n140 15.5561
R3461 VSS.n140 VSS.n139 15.5561
R3462 VSS.n139 VSS.n138 15.5561
R3463 VSS.n138 VSS.n137 15.5561
R3464 VSS.n137 VSS.n136 15.5561
R3465 VSS.n136 VSS.n135 15.5561
R3466 VSS.n135 VSS.n134 15.5561
R3467 VSS.n134 VSS.n133 15.5561
R3468 VSS.n133 VSS.n132 15.5561
R3469 VSS.n132 VSS.n131 15.5561
R3470 VSS.n131 VSS.n130 15.5561
R3471 VSS.n130 VSS.n129 15.5561
R3472 VSS.n129 VSS.n128 15.5561
R3473 VSS.n128 VSS.n127 15.5561
R3474 VSS.n127 VSS.n75 146.708
R3475 VSS.n153 VSS.n154 5.2005
R3476 VSS.n154 VSS.n77 5.2005
R3477 VSS.n155 VSS.n156 5.2005
R3478 VSS.n156 VSS.n124 5.2005
R3479 VSS.n157 VSS.n158 5.2005
R3480 VSS.n158 VSS.n122 5.2005
R3481 VSS.n159 VSS.n160 5.2005
R3482 VSS.n160 VSS.n120 5.2005
R3483 VSS.n161 VSS.n162 5.2005
R3484 VSS.n162 VSS.n118 5.2005
R3485 VSS.n163 VSS.n164 5.2005
R3486 VSS.n164 VSS.n116 5.2005
R3487 VSS.n165 VSS.n166 5.2005
R3488 VSS.n166 VSS.n114 5.2005
R3489 VSS.n167 VSS.n168 5.2005
R3490 VSS.n168 VSS.n112 5.2005
R3491 VSS.n169 VSS.n170 5.2005
R3492 VSS.n170 VSS.n110 5.2005
R3493 VSS.n171 VSS.n172 5.2005
R3494 VSS.n172 VSS.n108 5.2005
R3495 VSS.n173 VSS.n174 5.2005
R3496 VSS.n174 VSS.n106 5.2005
R3497 VSS.n175 VSS.n176 5.2005
R3498 VSS.n176 VSS.n104 5.2005
R3499 VSS.n177 VSS.n178 5.2005
R3500 VSS.n178 VSS.n102 5.2005
R3501 VSS.n179 VSS.n180 5.2005
R3502 VSS.n180 VSS.n100 5.2005
R3503 VSS.n181 VSS.n182 5.2005
R3504 VSS.n182 VSS.n98 5.2005
R3505 VSS.n183 VSS.n184 5.2005
R3506 VSS.n184 VSS.n96 5.2005
R3507 VSS.n185 VSS.n186 5.2005
R3508 VSS.n186 VSS.n94 5.2005
R3509 VSS.n187 VSS.n188 5.2005
R3510 VSS.n188 VSS.n92 5.2005
R3511 VSS.n189 VSS.n190 5.2005
R3512 VSS.n190 VSS.n90 5.2005
R3513 VSS.n191 VSS.n192 5.2005
R3514 VSS.n192 VSS.n88 5.2005
R3515 VSS.n193 VSS.n194 5.2005
R3516 VSS.n194 VSS.n86 5.2005
R3517 VSS.n195 VSS.n196 5.2005
R3518 VSS.n196 VSS.n84 5.2005
R3519 VSS.n197 VSS.n198 5.2005
R3520 VSS.n198 VSS.n82 5.2005
R3521 VSS.n199 VSS.n200 5.2005
R3522 VSS.n200 VSS.n80 5.2005
R3523 VSS.n201 VSS.n825 5.2005
R3524 VSS.n825 VSS.n826 5.2005
R3525 VSS.n827 VSS.n825 146.708
R3526 VSS.n825 VSS.n200 15.5561
R3527 VSS.n200 VSS.n198 15.5561
R3528 VSS.n198 VSS.n196 15.5561
R3529 VSS.n196 VSS.n194 15.5561
R3530 VSS.n194 VSS.n192 15.5561
R3531 VSS.n192 VSS.n190 15.5561
R3532 VSS.n190 VSS.n188 15.5561
R3533 VSS.n188 VSS.n186 15.5561
R3534 VSS.n186 VSS.n184 15.5561
R3535 VSS.n184 VSS.n182 15.5561
R3536 VSS.n182 VSS.n180 15.5561
R3537 VSS.n180 VSS.n178 15.5561
R3538 VSS.n178 VSS.n176 15.5561
R3539 VSS.n176 VSS.n174 15.5561
R3540 VSS.n174 VSS.n172 15.5561
R3541 VSS.n172 VSS.n170 15.5561
R3542 VSS.n170 VSS.n168 15.5561
R3543 VSS.n168 VSS.n166 15.5561
R3544 VSS.n166 VSS.n164 15.5561
R3545 VSS.n164 VSS.n162 15.5561
R3546 VSS.n162 VSS.n160 15.5561
R3547 VSS.n160 VSS.n158 15.5561
R3548 VSS.n158 VSS.n156 15.5561
R3549 VSS.n156 VSS.n154 15.5561
R3550 VSS.n154 VSS.n75 146.708
R3551 VSS.n826 VSS.n80 0.1445
R3552 VSS.n80 VSS.n82 0.1445
R3553 VSS.n82 VSS.n84 0.1445
R3554 VSS.n84 VSS.n86 0.1445
R3555 VSS.n86 VSS.n88 0.1445
R3556 VSS.n88 VSS.n90 0.1445
R3557 VSS.n90 VSS.n92 0.1445
R3558 VSS.n92 VSS.n94 0.1445
R3559 VSS.n94 VSS.n96 0.1445
R3560 VSS.n96 VSS.n98 0.1445
R3561 VSS.n98 VSS.n100 0.1445
R3562 VSS.n100 VSS.n102 0.1445
R3563 VSS.n102 VSS.n104 0.1445
R3564 VSS.n106 VSS.n104 0.1445
R3565 VSS.n108 VSS.n106 0.1445
R3566 VSS.n110 VSS.n108 0.1445
R3567 VSS.n112 VSS.n110 0.1445
R3568 VSS.n114 VSS.n112 0.1445
R3569 VSS.n116 VSS.n114 0.1445
R3570 VSS.n118 VSS.n116 0.1445
R3571 VSS.n120 VSS.n118 0.1445
R3572 VSS.n122 VSS.n120 0.1445
R3573 VSS.n124 VSS.n122 0.1445
R3574 VSS.n77 VSS.n124 0.1445
R3575 VSS.n202 VSS.n211 5.2005
R3576 VSS.n203 VSS.n202 5.2005
R3577 VSS.n204 VSS.n214 5.2005
R3578 VSS.n219 VSS.n204 5.2005
R3579 VSS.n206 VSS.n205 0.3255
R3580 VSS.n207 VSS.n206 0.3255
R3581 VSS.n209 VSS.n208 0.3255
R3582 VSS.n210 VSS.n209 0.3255
R3583 VSS.n211 VSS.n212 5.2005
R3584 VSS.n212 VSS.n213 5.2005
R3585 VSS.n214 VSS.n215 5.2005
R3586 VSS.n215 VSS.n216 5.2005
R3587 VSS.n223 VSS.n244 5.2005
R3588 VSS.n224 VSS.n223 5.2005
R3589 VSS.n225 VSS.n247 5.2005
R3590 VSS.n282 VSS.n225 5.2005
R3591 VSS.n226 VSS.n250 5.2005
R3592 VSS.n227 VSS.n226 5.2005
R3593 VSS.n228 VSS.n253 5.2005
R3594 VSS.n229 VSS.n228 5.2005
R3595 VSS.n230 VSS.n256 5.2005
R3596 VSS.n231 VSS.n230 5.2005
R3597 VSS.n232 VSS.n259 5.2005
R3598 VSS.n233 VSS.n232 5.2005
R3599 VSS.n234 VSS.n262 5.2005
R3600 VSS.n235 VSS.n234 5.2005
R3601 VSS.n236 VSS.n265 5.2005
R3602 VSS.n237 VSS.n236 5.2005
R3603 VSS.n239 VSS.n238 0.743357
R3604 VSS.n240 VSS.n239 0.743357
R3605 VSS.n242 VSS.n241 0.743357
R3606 VSS.n243 VSS.n242 0.743357
R3607 VSS.n244 VSS.n245 5.2005
R3608 VSS.n246 VSS.n245 5.2005
R3609 VSS.n247 VSS.n248 5.2005
R3610 VSS.n249 VSS.n248 5.2005
R3611 VSS.n250 VSS.n251 5.2005
R3612 VSS.n252 VSS.n251 5.2005
R3613 VSS.n253 VSS.n254 5.2005
R3614 VSS.n255 VSS.n254 5.2005
R3615 VSS.n256 VSS.n257 5.2005
R3616 VSS.n258 VSS.n257 5.2005
R3617 VSS.n259 VSS.n260 5.2005
R3618 VSS.n261 VSS.n260 5.2005
R3619 VSS.n262 VSS.n263 5.2005
R3620 VSS.n264 VSS.n263 5.2005
R3621 VSS.n265 VSS.n266 5.2005
R3622 VSS.n267 VSS.n266 5.2005
R3623 VSS.n286 VSS.n295 5.2005
R3624 VSS.n287 VSS.n286 5.2005
R3625 VSS.n288 VSS.n298 5.2005
R3626 VSS.n303 VSS.n288 5.2005
R3627 VSS.n290 VSS.n289 0.3255
R3628 VSS.n291 VSS.n290 0.3255
R3629 VSS.n293 VSS.n292 0.3255
R3630 VSS.n294 VSS.n293 0.3255
R3631 VSS.n295 VSS.n296 5.2005
R3632 VSS.n296 VSS.n297 5.2005
R3633 VSS.n298 VSS.n299 5.2005
R3634 VSS.n299 VSS.n300 5.2005
R3635 VSS.n307 VSS.n316 5.2005
R3636 VSS.n308 VSS.n307 5.2005
R3637 VSS.n309 VSS.n319 5.2005
R3638 VSS.n324 VSS.n309 5.2005
R3639 VSS.n311 VSS.n310 0.3255
R3640 VSS.n312 VSS.n311 0.3255
R3641 VSS.n314 VSS.n313 0.3255
R3642 VSS.n315 VSS.n314 0.3255
R3643 VSS.n316 VSS.n317 5.2005
R3644 VSS.n317 VSS.n318 5.2005
R3645 VSS.n319 VSS.n320 5.2005
R3646 VSS.n320 VSS.n321 5.2005
R3647 VSS.n328 VSS.n337 5.2005
R3648 VSS.n329 VSS.n328 5.2005
R3649 VSS.n330 VSS.n340 5.2005
R3650 VSS.n345 VSS.n330 5.2005
R3651 VSS.n332 VSS.n331 0.6505
R3652 VSS.n333 VSS.n332 0.6505
R3653 VSS.n335 VSS.n334 0.6505
R3654 VSS.n336 VSS.n335 0.6505
R3655 VSS.n337 VSS.n338 5.2005
R3656 VSS.n339 VSS.n338 5.2005
R3657 VSS.n340 VSS.n341 5.2005
R3658 VSS.n342 VSS.n341 5.2005
R3659 VSS.n349 VSS.n358 5.2005
R3660 VSS.n350 VSS.n349 5.2005
R3661 VSS.n351 VSS.n361 5.2005
R3662 VSS.n366 VSS.n351 5.2005
R3663 VSS.n353 VSS.n352 0.3255
R3664 VSS.n354 VSS.n353 0.3255
R3665 VSS.n356 VSS.n355 0.3255
R3666 VSS.n357 VSS.n356 0.3255
R3667 VSS.n358 VSS.n359 5.2005
R3668 VSS.n359 VSS.n360 5.2005
R3669 VSS.n361 VSS.n362 5.2005
R3670 VSS.n362 VSS.n363 5.2005
R3671 VSS.n373 VSS.n382 5.2005
R3672 VSS.n374 VSS.n373 5.2005
R3673 VSS.n375 VSS.n385 5.2005
R3674 VSS.n390 VSS.n375 5.2005
R3675 VSS.n377 VSS.n376 0.6505
R3676 VSS.n378 VSS.n377 0.6505
R3677 VSS.n380 VSS.n379 0.6505
R3678 VSS.n381 VSS.n380 0.6505
R3679 VSS.n382 VSS.n383 5.2005
R3680 VSS.n384 VSS.n383 5.2005
R3681 VSS.n385 VSS.n386 5.2005
R3682 VSS.n387 VSS.n386 5.2005
R3683 VSS.n394 VSS.n430 5.2005
R3684 VSS.n809 VSS.n394 5.2005
R3685 VSS.n395 VSS.n433 5.2005
R3686 VSS.n396 VSS.n395 5.2005
R3687 VSS.n397 VSS.n436 5.2005
R3688 VSS.n398 VSS.n397 5.2005
R3689 VSS.n399 VSS.n439 5.2005
R3690 VSS.n400 VSS.n399 5.2005
R3691 VSS.n401 VSS.n442 5.2005
R3692 VSS.n402 VSS.n401 5.2005
R3693 VSS.n403 VSS.n445 5.2005
R3694 VSS.n404 VSS.n403 5.2005
R3695 VSS.n405 VSS.n448 5.2005
R3696 VSS.n406 VSS.n405 5.2005
R3697 VSS.n407 VSS.n451 5.2005
R3698 VSS.n408 VSS.n407 5.2005
R3699 VSS.n409 VSS.n454 5.2005
R3700 VSS.n410 VSS.n409 5.2005
R3701 VSS.n411 VSS.n457 5.2005
R3702 VSS.n412 VSS.n411 5.2005
R3703 VSS.n413 VSS.n460 5.2005
R3704 VSS.n414 VSS.n413 5.2005
R3705 VSS.n415 VSS.n463 5.2005
R3706 VSS.n416 VSS.n415 5.2005
R3707 VSS.n417 VSS.n466 5.2005
R3708 VSS.n418 VSS.n417 5.2005
R3709 VSS.n419 VSS.n469 5.2005
R3710 VSS.n420 VSS.n419 5.2005
R3711 VSS.n421 VSS.n472 5.2005
R3712 VSS.n422 VSS.n421 5.2005
R3713 VSS.n423 VSS.n475 5.2005
R3714 VSS.n424 VSS.n423 5.2005
R3715 VSS.n425 VSS.n478 5.2005
R3716 VSS.n426 VSS.n425 5.2005
R3717 VSS.n428 VSS.n427 0.274184
R3718 VSS.n429 VSS.n428 0.274184
R3719 VSS.n430 VSS.n431 5.2005
R3720 VSS.n431 VSS.n432 5.2005
R3721 VSS.n433 VSS.n434 5.2005
R3722 VSS.n434 VSS.n435 5.2005
R3723 VSS.n436 VSS.n437 5.2005
R3724 VSS.n437 VSS.n438 5.2005
R3725 VSS.n439 VSS.n440 5.2005
R3726 VSS.n440 VSS.n441 5.2005
R3727 VSS.n442 VSS.n443 5.2005
R3728 VSS.n443 VSS.n444 5.2005
R3729 VSS.n445 VSS.n446 5.2005
R3730 VSS.n446 VSS.n447 5.2005
R3731 VSS.n448 VSS.n449 5.2005
R3732 VSS.n449 VSS.n450 5.2005
R3733 VSS.n451 VSS.n452 5.2005
R3734 VSS.n452 VSS.n453 5.2005
R3735 VSS.n454 VSS.n455 5.2005
R3736 VSS.n455 VSS.n456 5.2005
R3737 VSS.n457 VSS.n458 5.2005
R3738 VSS.n458 VSS.n459 5.2005
R3739 VSS.n460 VSS.n461 5.2005
R3740 VSS.n461 VSS.n462 5.2005
R3741 VSS.n463 VSS.n464 5.2005
R3742 VSS.n464 VSS.n465 5.2005
R3743 VSS.n466 VSS.n467 5.2005
R3744 VSS.n467 VSS.n468 5.2005
R3745 VSS.n469 VSS.n470 5.2005
R3746 VSS.n470 VSS.n471 5.2005
R3747 VSS.n472 VSS.n473 5.2005
R3748 VSS.n473 VSS.n474 5.2005
R3749 VSS.n475 VSS.n476 5.2005
R3750 VSS.n476 VSS.n477 5.2005
R3751 VSS.n478 VSS.n479 5.2005
R3752 VSS.n479 VSS.n480 5.2005
R3753 VSS.n238 VSS.n265 84.1452
R3754 VSS.n265 VSS.n262 57.5354
R3755 VSS.n262 VSS.n259 57.5354
R3756 VSS.n259 VSS.n256 57.5354
R3757 VSS.n256 VSS.t27 28.7679
R3758 VSS.n253 VSS.t27 28.7679
R3759 VSS.n253 VSS.n250 57.5354
R3760 VSS.n250 VSS.n247 57.5354
R3761 VSS.n247 VSS.n244 57.5354
R3762 VSS.n244 VSS.n241 84.1452
R3763 VSS.n241 VSS.n205 405.981
R3764 VSS.n205 VSS.n214 98.5289
R3765 VSS.n214 VSS.t49 28.7679
R3766 VSS.n211 VSS.t49 28.7679
R3767 VSS.n211 VSS.n208 98.5289
R3768 VSS.n208 VSS.n289 405.981
R3769 VSS.n289 VSS.n298 98.5289
R3770 VSS.n298 VSS.t51 28.7679
R3771 VSS.n295 VSS.t51 28.7679
R3772 VSS.n295 VSS.n292 98.5289
R3773 VSS.n292 VSS.n331 405.981
R3774 VSS.n331 VSS.n340 98.5289
R3775 VSS.n340 VSS.t53 28.7679
R3776 VSS.n337 VSS.t53 28.7679
R3777 VSS.n337 VSS.n334 98.5289
R3778 VSS.n334 VSS.n310 405.981
R3779 VSS.n310 VSS.n319 98.5289
R3780 VSS.n319 VSS.t38 28.7679
R3781 VSS.n316 VSS.t38 28.7679
R3782 VSS.n316 VSS.n313 98.5289
R3783 VSS.n313 VSS.n352 405.981
R3784 VSS.n352 VSS.n485 57.1758
R3785 VSS.n361 VSS.n485 41.3537
R3786 VSS.n361 VSS.t2 28.7679
R3787 VSS.n358 VSS.t2 28.7679
R3788 VSS.n358 VSS.n355 98.5289
R3789 VSS.n355 VSS.n126 405.981
R3790 VSS.n126 VSS.n201 81.9877
R3791 VSS.n201 VSS.t57 43.8708
R3792 VSS.n199 VSS.t57 13.665
R3793 VSS.n199 VSS.n197 57.5354
R3794 VSS.n197 VSS.n195 57.5354
R3795 VSS.n195 VSS.n193 57.5354
R3796 VSS.n193 VSS.t12 3.59643
R3797 VSS.t12 VSS.n191 53.9394
R3798 VSS.n191 VSS.n189 57.5354
R3799 VSS.n189 VSS.n187 57.5354
R3800 VSS.n187 VSS.t14 13.665
R3801 VSS.t14 VSS.n185 43.8708
R3802 VSS.n185 VSS.n183 57.5354
R3803 VSS.n183 VSS.n181 57.5354
R3804 VSS.n181 VSS.t3 23.7336
R3805 VSS.t3 VSS.n179 33.8022
R3806 VSS.n179 VSS.n177 57.5354
R3807 VSS.n177 VSS.n484 55.3778
R3808 VSS.n175 VSS.n484 2.15806
R3809 VSS.n175 VSS.t10 33.8022
R3810 VSS.n173 VSS.t10 23.7336
R3811 VSS.n173 VSS.n171 57.5354
R3812 VSS.n171 VSS.n169 57.5354
R3813 VSS.n169 VSS.t22 43.8708
R3814 VSS.n167 VSS.t22 13.665
R3815 VSS.n167 VSS.n165 57.5354
R3816 VSS.n165 VSS.n163 57.5354
R3817 VSS.n163 VSS.t24 53.9394
R3818 VSS.n161 VSS.t24 3.59643
R3819 VSS.n161 VSS.n159 57.5354
R3820 VSS.n159 VSS.n157 57.5354
R3821 VSS.n157 VSS.n155 57.5354
R3822 VSS.n155 VSS.t61 13.665
R3823 VSS.t61 VSS.n153 43.8708
R3824 VSS.n153 VSS.n74 81.9877
R3825 VSS.n74 VSS.n376 405.981
R3826 VSS.n376 VSS.n385 98.5289
R3827 VSS.n385 VSS.t47 28.7679
R3828 VSS.n382 VSS.t47 28.7679
R3829 VSS.n382 VSS.n379 98.5289
R3830 VSS.n379 VSS.n483 137.006
R3831 VSS.n483 VSS.n370 260.346
R3832 VSS.n370 VSS.t29 99.2481
R3833 VSS.t29 VSS.n482 1071.59
R3834 VSS.n372 VSS.n482 940.696
R3835 VSS.n372 VSS.n427 397.351
R3836 VSS.n427 VSS.n478 100.686
R3837 VSS.n478 VSS.t65 25.172
R3838 VSS.t65 VSS.n475 32.3639
R3839 VSS.n475 VSS.n472 57.5354
R3840 VSS.n472 VSS.n469 57.5354
R3841 VSS.n469 VSS.t36 42.4325
R3842 VSS.n466 VSS.t36 15.1034
R3843 VSS.n466 VSS.n463 57.5354
R3844 VSS.n463 VSS.n460 57.5354
R3845 VSS.n460 VSS.t5 52.5011
R3846 VSS.n457 VSS.t5 5.0348
R3847 VSS.n457 VSS.n454 57.5354
R3848 VSS.n454 VSS.n451 57.5354
R3849 VSS.n451 VSS.n448 57.5354
R3850 VSS.n448 VSS.t0 5.0348
R3851 VSS.t0 VSS.n445 52.5011
R3852 VSS.n445 VSS.n481 16.9014
R3853 VSS.n481 VSS.n442 40.6345
R3854 VSS.n442 VSS.n439 57.5354
R3855 VSS.n439 VSS.t18 15.1034
R3856 VSS.t18 VSS.n436 42.4325
R3857 VSS.n436 VSS.n433 57.5354
R3858 VSS.n433 VSS.n430 57.5354
R3859 VSS.n430 VSS.t69 32.3639
R3860 VSS.n238 VSS.n824 34168.5
R3861 VSS.n485 VSS.n824 19961.3
R3862 VSS.n489 VSS.n488 0.0477727
R3863 VSS.n490 VSS.n489 0.0477727
R3864 VSS.n492 VSS.n491 0.0477727
R3865 VSS.n500 VSS.n492 0.0477727
R3866 VSS.n486 VSS.t55 53.9567
R3867 VSS.t55 VSS.n824 954.861
R3868 VSS.n824 VSS.n487 1030.03
R3869 VSS.n487 VSS.n488 95.0256
R3870 VSS.n488 VSS.t31 66.6599
R3871 VSS.t31 VSS.t41 85.0976
R3872 VSS.t41 VSS.t46 85.0976
R3873 VSS.t46 VSS.t20 85.0976
R3874 VSS.t20 VSS.n821 71.6239
R3875 VSS.n821 VSS.t16 13.4742
R3876 VSS.t16 VSS.t26 85.0976
R3877 VSS.t26 VSS.t42 85.0976
R3878 VSS.t42 VSS.t43 85.0976
R3879 VSS.t17 VSS.t43 85.0976
R3880 VSS.t44 VSS.t17 85.0976
R3881 VSS.t45 VSS.t44 85.0976
R3882 VSS.t30 VSS.t45 85.0976
R3883 VSS.t7 VSS.t30 85.0976
R3884 VSS.n822 VSS.t7 52.477
R3885 VSS.n491 VSS.n822 14.1833
R3886 VSS.n491 VSS.n823 691.414
R3887 VSS.n482 VSS.n823 2123.87
R3888 VSS.n483 VSS.n822 2123.87
R3889 VSS.n484 VSS.n821 2123.87
R3890 VSS.n501 VSS.n823 4364.67
R3891 VSS.n481 VSS.n820 2048.26
R3892 VSS.n819 VSS.n820 2575.29
R3893 VSS.n502 VSS.n579 5.2005
R3894 VSS.n503 VSS.n502 5.2005
R3895 VSS.n504 VSS.n582 5.2005
R3896 VSS.n757 VSS.n504 5.2005
R3897 VSS.n505 VSS.n585 5.2005
R3898 VSS.n506 VSS.n505 5.2005
R3899 VSS.n507 VSS.n588 5.2005
R3900 VSS.n508 VSS.n507 5.2005
R3901 VSS.n509 VSS.n591 5.2005
R3902 VSS.n510 VSS.n509 5.2005
R3903 VSS.n511 VSS.n594 5.2005
R3904 VSS.n512 VSS.n511 5.2005
R3905 VSS.n513 VSS.n597 5.2005
R3906 VSS.n514 VSS.n513 5.2005
R3907 VSS.n515 VSS.n600 5.2005
R3908 VSS.n516 VSS.n515 5.2005
R3909 VSS.n517 VSS.n603 5.2005
R3910 VSS.n518 VSS.n517 5.2005
R3911 VSS.n519 VSS.n606 5.2005
R3912 VSS.n520 VSS.n519 5.2005
R3913 VSS.n521 VSS.n609 5.2005
R3914 VSS.n522 VSS.n521 5.2005
R3915 VSS.n523 VSS.n612 5.2005
R3916 VSS.n524 VSS.n523 5.2005
R3917 VSS.n525 VSS.n615 5.2005
R3918 VSS.n526 VSS.n525 5.2005
R3919 VSS.n527 VSS.n618 5.2005
R3920 VSS.n528 VSS.n527 5.2005
R3921 VSS.n529 VSS.n621 5.2005
R3922 VSS.n530 VSS.n529 5.2005
R3923 VSS.n531 VSS.n624 5.2005
R3924 VSS.n532 VSS.n531 5.2005
R3925 VSS.n533 VSS.n627 5.2005
R3926 VSS.n534 VSS.n533 5.2005
R3927 VSS.n535 VSS.n630 5.2005
R3928 VSS.n536 VSS.n535 5.2005
R3929 VSS.n537 VSS.n633 5.2005
R3930 VSS.n538 VSS.n537 5.2005
R3931 VSS.n539 VSS.n636 5.2005
R3932 VSS.n540 VSS.n539 5.2005
R3933 VSS.n541 VSS.n639 5.2005
R3934 VSS.n542 VSS.n541 5.2005
R3935 VSS.n543 VSS.n642 5.2005
R3936 VSS.n544 VSS.n543 5.2005
R3937 VSS.n545 VSS.n645 5.2005
R3938 VSS.n546 VSS.n545 5.2005
R3939 VSS.n547 VSS.n648 5.2005
R3940 VSS.n548 VSS.n547 5.2005
R3941 VSS.n549 VSS.n651 5.2005
R3942 VSS.n550 VSS.n549 5.2005
R3943 VSS.n551 VSS.n654 5.2005
R3944 VSS.n552 VSS.n551 5.2005
R3945 VSS.n553 VSS.n657 5.2005
R3946 VSS.n554 VSS.n553 5.2005
R3947 VSS.n555 VSS.n660 5.2005
R3948 VSS.n556 VSS.n555 5.2005
R3949 VSS.n557 VSS.n663 5.2005
R3950 VSS.n558 VSS.n557 5.2005
R3951 VSS.n559 VSS.n666 5.2005
R3952 VSS.n560 VSS.n559 5.2005
R3953 VSS.n561 VSS.n669 5.2005
R3954 VSS.n562 VSS.n561 5.2005
R3955 VSS.n563 VSS.n672 5.2005
R3956 VSS.n564 VSS.n563 5.2005
R3957 VSS.n565 VSS.n675 5.2005
R3958 VSS.n566 VSS.n565 5.2005
R3959 VSS.n567 VSS.n678 5.2005
R3960 VSS.n568 VSS.n567 5.2005
R3961 VSS.n569 VSS.n681 5.2005
R3962 VSS.n570 VSS.n569 5.2005
R3963 VSS.n571 VSS.n684 5.2005
R3964 VSS.n572 VSS.n571 5.2005
R3965 VSS.n574 VSS.n573 0.149071
R3966 VSS.n575 VSS.n574 0.149071
R3967 VSS.n577 VSS.n576 0.149071
R3968 VSS.n578 VSS.n577 0.149071
R3969 VSS.n579 VSS.n580 5.2005
R3970 VSS.n580 VSS.n581 5.2005
R3971 VSS.n582 VSS.n583 5.2005
R3972 VSS.n583 VSS.n584 5.2005
R3973 VSS.n585 VSS.n586 5.2005
R3974 VSS.n586 VSS.n587 5.2005
R3975 VSS.n588 VSS.n589 5.2005
R3976 VSS.n589 VSS.n590 5.2005
R3977 VSS.n591 VSS.n592 5.2005
R3978 VSS.n592 VSS.n593 5.2005
R3979 VSS.n594 VSS.n595 5.2005
R3980 VSS.n595 VSS.n596 5.2005
R3981 VSS.n597 VSS.n598 5.2005
R3982 VSS.n598 VSS.n599 5.2005
R3983 VSS.n600 VSS.n601 5.2005
R3984 VSS.n601 VSS.n602 5.2005
R3985 VSS.n603 VSS.n604 5.2005
R3986 VSS.n604 VSS.n605 5.2005
R3987 VSS.n606 VSS.n607 5.2005
R3988 VSS.n607 VSS.n608 5.2005
R3989 VSS.n609 VSS.n610 5.2005
R3990 VSS.n610 VSS.n611 5.2005
R3991 VSS.n612 VSS.n613 5.2005
R3992 VSS.n613 VSS.n614 5.2005
R3993 VSS.n615 VSS.n616 5.2005
R3994 VSS.n616 VSS.n617 5.2005
R3995 VSS.n618 VSS.n619 5.2005
R3996 VSS.n619 VSS.n620 5.2005
R3997 VSS.n621 VSS.n622 5.2005
R3998 VSS.n622 VSS.n623 5.2005
R3999 VSS.n624 VSS.n625 5.2005
R4000 VSS.n625 VSS.n626 5.2005
R4001 VSS.n627 VSS.n628 5.2005
R4002 VSS.n628 VSS.n629 5.2005
R4003 VSS.n630 VSS.n631 5.2005
R4004 VSS.n631 VSS.n632 5.2005
R4005 VSS.n633 VSS.n634 5.2005
R4006 VSS.n634 VSS.n635 5.2005
R4007 VSS.n636 VSS.n637 5.2005
R4008 VSS.n637 VSS.n638 5.2005
R4009 VSS.n639 VSS.n640 5.2005
R4010 VSS.n640 VSS.n641 5.2005
R4011 VSS.n642 VSS.n643 5.2005
R4012 VSS.n643 VSS.n644 5.2005
R4013 VSS.n645 VSS.n646 5.2005
R4014 VSS.n646 VSS.n647 5.2005
R4015 VSS.n648 VSS.n649 5.2005
R4016 VSS.n649 VSS.n650 5.2005
R4017 VSS.n651 VSS.n652 5.2005
R4018 VSS.n652 VSS.n653 5.2005
R4019 VSS.n654 VSS.n655 5.2005
R4020 VSS.n655 VSS.n656 5.2005
R4021 VSS.n657 VSS.n658 5.2005
R4022 VSS.n658 VSS.n659 5.2005
R4023 VSS.n660 VSS.n661 5.2005
R4024 VSS.n661 VSS.n662 5.2005
R4025 VSS.n663 VSS.n664 5.2005
R4026 VSS.n664 VSS.n665 5.2005
R4027 VSS.n666 VSS.n667 5.2005
R4028 VSS.n667 VSS.n668 5.2005
R4029 VSS.n669 VSS.n670 5.2005
R4030 VSS.n670 VSS.n671 5.2005
R4031 VSS.n672 VSS.n673 5.2005
R4032 VSS.n673 VSS.n674 5.2005
R4033 VSS.n675 VSS.n676 5.2005
R4034 VSS.n676 VSS.n677 5.2005
R4035 VSS.n678 VSS.n679 5.2005
R4036 VSS.n679 VSS.n680 5.2005
R4037 VSS.n681 VSS.n682 5.2005
R4038 VSS.n682 VSS.n683 5.2005
R4039 VSS.n684 VSS.n685 5.2005
R4040 VSS.n685 VSS.n686 5.2005
R4041 VSS.n767 VSS.n772 5.2005
R4042 VSS.n768 VSS.n767 5.2005
R4043 VSS.n770 VSS.n769 0.274184
R4044 VSS.n771 VSS.n770 0.274184
R4045 VSS.n772 VSS.n773 5.2005
R4046 VSS.n773 VSS.n774 5.2005
R4047 VSS.n772 VSS.t69 25.172
R4048 VSS.n772 VSS.n769 100.686
R4049 VSS.n769 VSS.n819 126.218
R4050 VSS.n819 VSS.n573 279.764
R4051 VSS.n573 VSS.n684 100.686
R4052 VSS.n684 VSS.n681 57.5354
R4053 VSS.n681 VSS.t73 53.9394
R4054 VSS.n678 VSS.t73 3.59643
R4055 VSS.n678 VSS.n675 57.5354
R4056 VSS.n675 VSS.n672 57.5354
R4057 VSS.n672 VSS.n669 57.5354
R4058 VSS.n669 VSS.n666 57.5354
R4059 VSS.n666 VSS.n663 57.5354
R4060 VSS.n663 VSS.n660 57.5354
R4061 VSS.n660 VSS.t39 13.665
R4062 VSS.t39 VSS.n657 43.8708
R4063 VSS.n657 VSS.n654 57.5354
R4064 VSS.n654 VSS.n651 57.5354
R4065 VSS.n651 VSS.n648 57.5354
R4066 VSS.n648 VSS.n645 57.5354
R4067 VSS.n645 VSS.n642 57.5354
R4068 VSS.n642 VSS.t34 23.7336
R4069 VSS.t34 VSS.n639 33.8022
R4070 VSS.n639 VSS.n636 57.5354
R4071 VSS.n636 VSS.n633 57.5354
R4072 VSS.n633 VSS.n630 57.5354
R4073 VSS.n630 VSS.n627 57.5354
R4074 VSS.n627 VSS.n624 57.5354
R4075 VSS.n624 VSS.t35 33.8022
R4076 VSS.n621 VSS.t35 23.7336
R4077 VSS.n621 VSS.n618 57.5354
R4078 VSS.n618 VSS.n615 57.5354
R4079 VSS.n615 VSS.n612 57.5354
R4080 VSS.n612 VSS.n609 57.5354
R4081 VSS.n609 VSS.n606 57.5354
R4082 VSS.n606 VSS.t40 43.8708
R4083 VSS.n603 VSS.t40 13.665
R4084 VSS.n603 VSS.n600 57.5354
R4085 VSS.n600 VSS.n597 57.5354
R4086 VSS.n597 VSS.n594 57.5354
R4087 VSS.n594 VSS.n591 57.5354
R4088 VSS.n591 VSS.n588 57.5354
R4089 VSS.n588 VSS.n585 57.5354
R4090 VSS.n585 VSS.t77 3.59643
R4091 VSS.t77 VSS.n582 53.9394
R4092 VSS.n582 VSS.n579 57.5354
R4093 VSS.n579 VSS.n576 100.686
R4094 VSS.n820 VSS.n501 2492.04
R4095 VSS.n501 VSS.n576 29020.7
R4096 VSS.n775 VSS.n774 4.5005
R4097 VSS.n776 VSS.n480 4.5005
R4098 VSS.n777 VSS.n477 4.5005
R4099 VSS.n778 VSS.n474 4.5005
R4100 VSS.n779 VSS.n471 4.5005
R4101 VSS.n780 VSS.n468 4.5005
R4102 VSS.n781 VSS.n465 4.5005
R4103 VSS.n462 VSS.n782 4.5005
R4104 VSS.n783 VSS.n459 4.5005
R4105 VSS.n784 VSS.n456 4.5005
R4106 VSS.n785 VSS.n453 4.5005
R4107 VSS.n786 VSS.n450 4.5005
R4108 VSS.n787 VSS.n447 4.5005
R4109 VSS.n788 VSS.n444 4.5005
R4110 VSS.n789 VSS.n441 4.5005
R4111 VSS.n790 VSS.n438 4.5005
R4112 VSS.n791 VSS.n435 4.5005
R4113 VSS.n818 VSS.n432 4.5005
R4114 VSS.n480 VSS.n477 0.1445
R4115 VSS.n477 VSS.n474 0.1445
R4116 VSS.n474 VSS.n471 0.1445
R4117 VSS.n471 VSS.n468 0.1445
R4118 VSS.n468 VSS.n465 0.1445
R4119 VSS.n465 VSS.n462 0.1445
R4120 VSS.n459 VSS.n462 0.1445
R4121 VSS.n459 VSS.n456 0.1445
R4122 VSS.n456 VSS.n453 0.1445
R4123 VSS.n453 VSS.n450 0.1445
R4124 VSS.n450 VSS.n447 0.1445
R4125 VSS.n447 VSS.n444 0.1445
R4126 VSS.n444 VSS.n441 0.1445
R4127 VSS.n441 VSS.n438 0.1445
R4128 VSS.n438 VSS.n435 0.1445
R4129 VSS.n435 VSS.n432 0.1445
R4130 VSS.n432 VSS.n774 0.1445
R4131 VSS.n777 VSS.n776 0.1445
R4132 VSS.n778 VSS.n777 0.1445
R4133 VSS.n779 VSS.n778 0.1445
R4134 VSS.n780 VSS.n779 0.1445
R4135 VSS.n781 VSS.n780 0.1445
R4136 VSS.n782 VSS.n781 0.1445
R4137 VSS.n783 VSS.n782 0.1445
R4138 VSS.n784 VSS.n783 0.1445
R4139 VSS.n785 VSS.n784 0.1445
R4140 VSS.n786 VSS.n785 0.1445
R4141 VSS.n787 VSS.n786 0.1445
R4142 VSS.n788 VSS.n787 0.1445
R4143 VSS.n789 VSS.n788 0.1445
R4144 VSS.n790 VSS.n789 0.1445
R4145 VSS.n791 VSS.n790 0.1445
R4146 VSS.n818 VSS.n791 0.1445
R4147 VSS.n775 VSS.n818 0.1445
R4148 VSS.n815 VSS.n771 0.473978
R4149 VSS.n771 VSS.n775 5.71542
R4150 VSS.n817 VSS.n816 0.113978
R4151 VSS.n815 VSS.n817 0.229413
R4152 VSS.n816 VSS.t70 2.6861
R4153 VSS.n817 VSS.t71 2.57262
R4154 VSS.n816 VSS.t68 30.2232
R4155 VSS.n814 VSS.n815 4.97734
R4156 VSS.n792 VSS.n768 4.5005
R4157 VSS.n793 VSS.n426 4.5005
R4158 VSS.n794 VSS.n424 4.5005
R4159 VSS.n795 VSS.n422 4.5005
R4160 VSS.n420 VSS.n796 4.5005
R4161 VSS.n797 VSS.n418 4.5005
R4162 VSS.n798 VSS.n416 4.5005
R4163 VSS.n799 VSS.n414 4.5005
R4164 VSS.n800 VSS.n412 4.5005
R4165 VSS.n801 VSS.n410 4.5005
R4166 VSS.n802 VSS.n408 4.5005
R4167 VSS.n803 VSS.n406 4.5005
R4168 VSS.n404 VSS.n804 4.5005
R4169 VSS.n402 VSS.n805 4.5005
R4170 VSS.n400 VSS.n806 4.5005
R4171 VSS.n398 VSS.n807 4.5005
R4172 VSS.n396 VSS.n808 4.5005
R4173 VSS.n809 VSS.n810 4.5005
R4174 VSS.n794 VSS.n793 0.1445
R4175 VSS.n795 VSS.n794 0.1445
R4176 VSS.n796 VSS.n795 0.1445
R4177 VSS.n797 VSS.n796 0.1445
R4178 VSS.n798 VSS.n797 0.1445
R4179 VSS.n799 VSS.n798 0.1445
R4180 VSS.n800 VSS.n799 0.1445
R4181 VSS.n801 VSS.n800 0.1445
R4182 VSS.n802 VSS.n801 0.1445
R4183 VSS.n803 VSS.n802 0.1445
R4184 VSS.n804 VSS.n803 0.1445
R4185 VSS.n805 VSS.n804 0.1445
R4186 VSS.n806 VSS.n805 0.1445
R4187 VSS.n807 VSS.n806 0.1445
R4188 VSS.n808 VSS.n807 0.1445
R4189 VSS.n810 VSS.n808 0.1445
R4190 VSS.n792 VSS.n810 0.1445
R4191 VSS.n814 VSS.n792 0.1751
R4192 VSS.n21 VSS.n814 9.48839
R4193 VSS.n793 VSS.n811 5.15194
R4194 VSS.n811 VSS.n813 0.229413
R4195 VSS.n813 VSS.n812 0.113978
R4196 VSS.n813 VSS.t66 2.57262
R4197 VSS.n812 VSS.t67 2.6861
R4198 VSS.n812 VSS.t64 30.2232
R4199 VSS.n811 VSS.n429 0.473978
R4200 VSS.n429 VSS.n776 5.71542
R4201 VSS.n426 VSS.n424 0.1445
R4202 VSS.n424 VSS.n422 0.1445
R4203 VSS.n422 VSS.n420 0.1445
R4204 VSS.n418 VSS.n420 0.1445
R4205 VSS.n418 VSS.n416 0.1445
R4206 VSS.n416 VSS.n414 0.1445
R4207 VSS.n414 VSS.n412 0.1445
R4208 VSS.n412 VSS.n410 0.1445
R4209 VSS.n410 VSS.n408 0.1445
R4210 VSS.n408 VSS.n406 0.1445
R4211 VSS.n406 VSS.n404 0.1445
R4212 VSS.n402 VSS.n404 0.1445
R4213 VSS.n400 VSS.n402 0.1445
R4214 VSS.n398 VSS.n400 0.1445
R4215 VSS.n396 VSS.n398 0.1445
R4216 VSS.n809 VSS.n396 0.1445
R4217 VSS.n768 VSS.n809 0.1445
R4218 VSS.n479 VSS.n476 15.5561
R4219 VSS.n476 VSS.n473 15.5561
R4220 VSS.n473 VSS.n470 15.5561
R4221 VSS.n470 VSS.n467 15.5561
R4222 VSS.n467 VSS.n464 15.5561
R4223 VSS.n464 VSS.n461 15.5561
R4224 VSS.n461 VSS.n458 15.5561
R4225 VSS.n458 VSS.n455 15.5561
R4226 VSS.n455 VSS.n452 15.5561
R4227 VSS.n452 VSS.n449 15.5561
R4228 VSS.n449 VSS.n446 15.5561
R4229 VSS.n446 VSS.n443 15.5561
R4230 VSS.n443 VSS.n440 15.5561
R4231 VSS.n440 VSS.n437 15.5561
R4232 VSS.n437 VSS.n434 15.5561
R4233 VSS.n434 VSS.n431 15.5561
R4234 VSS.n431 VSS.n773 15.5561
R4235 VSS.n770 VSS.n773 120.168
R4236 VSS.n425 VSS.n423 15.5561
R4237 VSS.n423 VSS.n421 15.5561
R4238 VSS.n421 VSS.n419 15.5561
R4239 VSS.n419 VSS.n417 15.5561
R4240 VSS.n417 VSS.n415 15.5561
R4241 VSS.n415 VSS.n413 15.5561
R4242 VSS.n413 VSS.n411 15.5561
R4243 VSS.n411 VSS.n409 15.5561
R4244 VSS.n409 VSS.n407 15.5561
R4245 VSS.n407 VSS.n405 15.5561
R4246 VSS.n405 VSS.n403 15.5561
R4247 VSS.n403 VSS.n401 15.5561
R4248 VSS.n401 VSS.n399 15.5561
R4249 VSS.n399 VSS.n397 15.5561
R4250 VSS.n397 VSS.n395 15.5561
R4251 VSS.n395 VSS.n394 15.5561
R4252 VSS.n394 VSS.n767 15.5561
R4253 VSS.n767 VSS.n770 120.168
R4254 VSS.n425 VSS.n428 120.168
R4255 VSS.n428 VSS.n479 120.168
R4256 VSS.n687 VSS.n581 4.5005
R4257 VSS.n686 VSS.n688 4.5005
R4258 VSS.n683 VSS.n689 4.5005
R4259 VSS.n690 VSS.n680 4.5005
R4260 VSS.n691 VSS.n677 4.5005
R4261 VSS.n692 VSS.n674 4.5005
R4262 VSS.n693 VSS.n671 4.5005
R4263 VSS.n694 VSS.n668 4.5005
R4264 VSS.n665 VSS.n695 4.5005
R4265 VSS.n696 VSS.n662 4.5005
R4266 VSS.n659 VSS.n697 4.5005
R4267 VSS.n698 VSS.n656 4.5005
R4268 VSS.n699 VSS.n653 4.5005
R4269 VSS.n650 VSS.n700 4.5005
R4270 VSS.n647 VSS.n701 4.5005
R4271 VSS.n702 VSS.n644 4.5005
R4272 VSS.n703 VSS.n641 4.5005
R4273 VSS.n638 VSS.n704 4.5005
R4274 VSS.n705 VSS.n635 4.5005
R4275 VSS.n706 VSS.n632 4.5005
R4276 VSS.n707 VSS.n629 4.5005
R4277 VSS.n708 VSS.n626 4.5005
R4278 VSS.n709 VSS.n623 4.5005
R4279 VSS.n710 VSS.n620 4.5005
R4280 VSS.n711 VSS.n617 4.5005
R4281 VSS.n712 VSS.n614 4.5005
R4282 VSS.n713 VSS.n611 4.5005
R4283 VSS.n714 VSS.n608 4.5005
R4284 VSS.n715 VSS.n605 4.5005
R4285 VSS.n716 VSS.n602 4.5005
R4286 VSS.n717 VSS.n599 4.5005
R4287 VSS.n596 VSS.n718 4.5005
R4288 VSS.n719 VSS.n593 4.5005
R4289 VSS.n720 VSS.n590 4.5005
R4290 VSS.n721 VSS.n587 4.5005
R4291 VSS.n766 VSS.n584 4.5005
R4292 VSS.n683 VSS.n686 0.1445
R4293 VSS.n680 VSS.n683 0.1445
R4294 VSS.n680 VSS.n677 0.1445
R4295 VSS.n677 VSS.n674 0.1445
R4296 VSS.n674 VSS.n671 0.1445
R4297 VSS.n671 VSS.n668 0.1445
R4298 VSS.n668 VSS.n665 0.1445
R4299 VSS.n662 VSS.n665 0.1445
R4300 VSS.n662 VSS.n659 0.1445
R4301 VSS.n656 VSS.n659 0.1445
R4302 VSS.n656 VSS.n653 0.1445
R4303 VSS.n653 VSS.n650 0.1445
R4304 VSS.n647 VSS.n650 0.1445
R4305 VSS.n644 VSS.n647 0.1445
R4306 VSS.n644 VSS.n641 0.1445
R4307 VSS.n641 VSS.n638 0.1445
R4308 VSS.n635 VSS.n638 0.1445
R4309 VSS.n635 VSS.n632 0.1445
R4310 VSS.n632 VSS.n629 0.1445
R4311 VSS.n629 VSS.n626 0.1445
R4312 VSS.n626 VSS.n623 0.1445
R4313 VSS.n623 VSS.n620 0.1445
R4314 VSS.n620 VSS.n617 0.1445
R4315 VSS.n617 VSS.n614 0.1445
R4316 VSS.n614 VSS.n611 0.1445
R4317 VSS.n611 VSS.n608 0.1445
R4318 VSS.n608 VSS.n605 0.1445
R4319 VSS.n605 VSS.n602 0.1445
R4320 VSS.n602 VSS.n599 0.1445
R4321 VSS.n599 VSS.n596 0.1445
R4322 VSS.n593 VSS.n596 0.1445
R4323 VSS.n593 VSS.n590 0.1445
R4324 VSS.n590 VSS.n587 0.1445
R4325 VSS.n587 VSS.n584 0.1445
R4326 VSS.n584 VSS.n581 0.1445
R4327 VSS.n689 VSS.n688 0.1445
R4328 VSS.n690 VSS.n689 0.1445
R4329 VSS.n691 VSS.n690 0.1445
R4330 VSS.n692 VSS.n691 0.1445
R4331 VSS.n693 VSS.n692 0.1445
R4332 VSS.n694 VSS.n693 0.1445
R4333 VSS.n695 VSS.n694 0.1445
R4334 VSS.n696 VSS.n695 0.1445
R4335 VSS.n697 VSS.n696 0.1445
R4336 VSS.n698 VSS.n697 0.1445
R4337 VSS.n699 VSS.n698 0.1445
R4338 VSS.n700 VSS.n699 0.1445
R4339 VSS.n701 VSS.n700 0.1445
R4340 VSS.n702 VSS.n701 0.1445
R4341 VSS.n703 VSS.n702 0.1445
R4342 VSS.n704 VSS.n703 0.1445
R4343 VSS.n705 VSS.n704 0.1445
R4344 VSS.n706 VSS.n705 0.1445
R4345 VSS.n707 VSS.n706 0.1445
R4346 VSS.n708 VSS.n707 0.1445
R4347 VSS.n709 VSS.n708 0.1445
R4348 VSS.n710 VSS.n709 0.1445
R4349 VSS.n711 VSS.n710 0.1445
R4350 VSS.n712 VSS.n711 0.1445
R4351 VSS.n713 VSS.n712 0.1445
R4352 VSS.n714 VSS.n713 0.1445
R4353 VSS.n715 VSS.n714 0.1445
R4354 VSS.n716 VSS.n715 0.1445
R4355 VSS.n717 VSS.n716 0.1445
R4356 VSS.n718 VSS.n717 0.1445
R4357 VSS.n719 VSS.n718 0.1445
R4358 VSS.n720 VSS.n719 0.1445
R4359 VSS.n721 VSS.n720 0.1445
R4360 VSS.n766 VSS.n721 0.1445
R4361 VSS.n687 VSS.n766 0.1445
R4362 VSS.n763 VSS.n578 1.2067
R4363 VSS.n578 VSS.n687 6.4501
R4364 VSS.n765 VSS.n764 0.348761
R4365 VSS.n763 VSS.n765 0.229413
R4366 VSS.n764 VSS.t78 1.86538
R4367 VSS.n765 VSS.t79 1.51712
R4368 VSS.n764 VSS.t76 27.3122
R4369 VSS.n762 VSS.n763 4.9793
R4370 VSS.n722 VSS.n503 4.5005
R4371 VSS.n723 VSS.n572 4.5005
R4372 VSS.n724 VSS.n570 4.5005
R4373 VSS.n725 VSS.n568 4.5005
R4374 VSS.n726 VSS.n566 4.5005
R4375 VSS.n727 VSS.n564 4.5005
R4376 VSS.n728 VSS.n562 4.5005
R4377 VSS.n729 VSS.n560 4.5005
R4378 VSS.n558 VSS.n730 4.5005
R4379 VSS.n731 VSS.n556 4.5005
R4380 VSS.n732 VSS.n554 4.5005
R4381 VSS.n733 VSS.n552 4.5005
R4382 VSS.n550 VSS.n734 4.5005
R4383 VSS.n548 VSS.n735 4.5005
R4384 VSS.n736 VSS.n546 4.5005
R4385 VSS.n737 VSS.n544 4.5005
R4386 VSS.n542 VSS.n738 4.5005
R4387 VSS.n540 VSS.n739 4.5005
R4388 VSS.n538 VSS.n740 4.5005
R4389 VSS.n536 VSS.n741 4.5005
R4390 VSS.n742 VSS.n534 4.5005
R4391 VSS.n743 VSS.n532 4.5005
R4392 VSS.n744 VSS.n530 4.5005
R4393 VSS.n528 VSS.n745 4.5005
R4394 VSS.n526 VSS.n746 4.5005
R4395 VSS.n524 VSS.n747 4.5005
R4396 VSS.n522 VSS.n748 4.5005
R4397 VSS.n520 VSS.n749 4.5005
R4398 VSS.n518 VSS.n750 4.5005
R4399 VSS.n516 VSS.n751 4.5005
R4400 VSS.n514 VSS.n752 4.5005
R4401 VSS.n512 VSS.n753 4.5005
R4402 VSS.n510 VSS.n754 4.5005
R4403 VSS.n508 VSS.n755 4.5005
R4404 VSS.n506 VSS.n756 4.5005
R4405 VSS.n757 VSS.n758 4.5005
R4406 VSS.n724 VSS.n723 0.1445
R4407 VSS.n725 VSS.n724 0.1445
R4408 VSS.n726 VSS.n725 0.1445
R4409 VSS.n727 VSS.n726 0.1445
R4410 VSS.n728 VSS.n727 0.1445
R4411 VSS.n729 VSS.n728 0.1445
R4412 VSS.n730 VSS.n729 0.1445
R4413 VSS.n731 VSS.n730 0.1445
R4414 VSS.n732 VSS.n731 0.1445
R4415 VSS.n733 VSS.n732 0.1445
R4416 VSS.n734 VSS.n733 0.1445
R4417 VSS.n735 VSS.n734 0.1445
R4418 VSS.n736 VSS.n735 0.1445
R4419 VSS.n737 VSS.n736 0.1445
R4420 VSS.n738 VSS.n737 0.1445
R4421 VSS.n739 VSS.n738 0.1445
R4422 VSS.n740 VSS.n739 0.1445
R4423 VSS.n741 VSS.n740 0.1445
R4424 VSS.n742 VSS.n741 0.1445
R4425 VSS.n743 VSS.n742 0.1445
R4426 VSS.n744 VSS.n743 0.1445
R4427 VSS.n745 VSS.n744 0.1445
R4428 VSS.n746 VSS.n745 0.1445
R4429 VSS.n747 VSS.n746 0.1445
R4430 VSS.n748 VSS.n747 0.1445
R4431 VSS.n749 VSS.n748 0.1445
R4432 VSS.n750 VSS.n749 0.1445
R4433 VSS.n751 VSS.n750 0.1445
R4434 VSS.n752 VSS.n751 0.1445
R4435 VSS.n753 VSS.n752 0.1445
R4436 VSS.n754 VSS.n753 0.1445
R4437 VSS.n755 VSS.n754 0.1445
R4438 VSS.n756 VSS.n755 0.1445
R4439 VSS.n758 VSS.n756 0.1445
R4440 VSS.n722 VSS.n758 0.1445
R4441 VSS.n762 VSS.n722 0.1751
R4442 VSS.n723 VSS.n759 5.1539
R4443 VSS.n759 VSS.n761 0.229413
R4444 VSS.n761 VSS.n760 0.348761
R4445 VSS.n761 VSS.t74 1.51712
R4446 VSS.n760 VSS.t75 1.86538
R4447 VSS.n760 VSS.t72 27.3122
R4448 VSS.n759 VSS.n575 1.2067
R4449 VSS.n575 VSS.n688 6.4501
R4450 VSS.n572 VSS.n570 0.1445
R4451 VSS.n570 VSS.n568 0.1445
R4452 VSS.n568 VSS.n566 0.1445
R4453 VSS.n566 VSS.n564 0.1445
R4454 VSS.n564 VSS.n562 0.1445
R4455 VSS.n562 VSS.n560 0.1445
R4456 VSS.n560 VSS.n558 0.1445
R4457 VSS.n556 VSS.n558 0.1445
R4458 VSS.n556 VSS.n554 0.1445
R4459 VSS.n554 VSS.n552 0.1445
R4460 VSS.n552 VSS.n550 0.1445
R4461 VSS.n548 VSS.n550 0.1445
R4462 VSS.n546 VSS.n548 0.1445
R4463 VSS.n546 VSS.n544 0.1445
R4464 VSS.n544 VSS.n542 0.1445
R4465 VSS.n540 VSS.n542 0.1445
R4466 VSS.n538 VSS.n540 0.1445
R4467 VSS.n536 VSS.n538 0.1445
R4468 VSS.n534 VSS.n536 0.1445
R4469 VSS.n534 VSS.n532 0.1445
R4470 VSS.n532 VSS.n530 0.1445
R4471 VSS.n530 VSS.n528 0.1445
R4472 VSS.n526 VSS.n528 0.1445
R4473 VSS.n524 VSS.n526 0.1445
R4474 VSS.n522 VSS.n524 0.1445
R4475 VSS.n520 VSS.n522 0.1445
R4476 VSS.n518 VSS.n520 0.1445
R4477 VSS.n516 VSS.n518 0.1445
R4478 VSS.n514 VSS.n516 0.1445
R4479 VSS.n512 VSS.n514 0.1445
R4480 VSS.n510 VSS.n512 0.1445
R4481 VSS.n508 VSS.n510 0.1445
R4482 VSS.n506 VSS.n508 0.1445
R4483 VSS.n757 VSS.n506 0.1445
R4484 VSS.n503 VSS.n757 0.1445
R4485 VSS.n685 VSS.n682 15.5561
R4486 VSS.n682 VSS.n679 15.5561
R4487 VSS.n679 VSS.n676 15.5561
R4488 VSS.n676 VSS.n673 15.5561
R4489 VSS.n673 VSS.n670 15.5561
R4490 VSS.n670 VSS.n667 15.5561
R4491 VSS.n667 VSS.n664 15.5561
R4492 VSS.n664 VSS.n661 15.5561
R4493 VSS.n661 VSS.n658 15.5561
R4494 VSS.n658 VSS.n655 15.5561
R4495 VSS.n655 VSS.n652 15.5561
R4496 VSS.n652 VSS.n649 15.5561
R4497 VSS.n649 VSS.n646 15.5561
R4498 VSS.n646 VSS.n643 15.5561
R4499 VSS.n643 VSS.n640 15.5561
R4500 VSS.n640 VSS.n637 15.5561
R4501 VSS.n637 VSS.n634 15.5561
R4502 VSS.n634 VSS.n631 15.5561
R4503 VSS.n631 VSS.n628 15.5561
R4504 VSS.n628 VSS.n625 15.5561
R4505 VSS.n625 VSS.n622 15.5561
R4506 VSS.n622 VSS.n619 15.5561
R4507 VSS.n619 VSS.n616 15.5561
R4508 VSS.n616 VSS.n613 15.5561
R4509 VSS.n613 VSS.n610 15.5561
R4510 VSS.n610 VSS.n607 15.5561
R4511 VSS.n607 VSS.n604 15.5561
R4512 VSS.n604 VSS.n601 15.5561
R4513 VSS.n601 VSS.n598 15.5561
R4514 VSS.n598 VSS.n595 15.5561
R4515 VSS.n595 VSS.n592 15.5561
R4516 VSS.n592 VSS.n589 15.5561
R4517 VSS.n589 VSS.n586 15.5561
R4518 VSS.n586 VSS.n583 15.5561
R4519 VSS.n583 VSS.n580 15.5561
R4520 VSS.n577 VSS.n580 193.181
R4521 VSS.n571 VSS.n569 15.5561
R4522 VSS.n569 VSS.n567 15.5561
R4523 VSS.n567 VSS.n565 15.5561
R4524 VSS.n565 VSS.n563 15.5561
R4525 VSS.n563 VSS.n561 15.5561
R4526 VSS.n561 VSS.n559 15.5561
R4527 VSS.n559 VSS.n557 15.5561
R4528 VSS.n557 VSS.n555 15.5561
R4529 VSS.n555 VSS.n553 15.5561
R4530 VSS.n553 VSS.n551 15.5561
R4531 VSS.n551 VSS.n549 15.5561
R4532 VSS.n549 VSS.n547 15.5561
R4533 VSS.n547 VSS.n545 15.5561
R4534 VSS.n545 VSS.n543 15.5561
R4535 VSS.n543 VSS.n541 15.5561
R4536 VSS.n541 VSS.n539 15.5561
R4537 VSS.n539 VSS.n537 15.5561
R4538 VSS.n537 VSS.n535 15.5561
R4539 VSS.n535 VSS.n533 15.5561
R4540 VSS.n533 VSS.n531 15.5561
R4541 VSS.n531 VSS.n529 15.5561
R4542 VSS.n529 VSS.n527 15.5561
R4543 VSS.n527 VSS.n525 15.5561
R4544 VSS.n525 VSS.n523 15.5561
R4545 VSS.n523 VSS.n521 15.5561
R4546 VSS.n521 VSS.n519 15.5561
R4547 VSS.n519 VSS.n517 15.5561
R4548 VSS.n517 VSS.n515 15.5561
R4549 VSS.n515 VSS.n513 15.5561
R4550 VSS.n513 VSS.n511 15.5561
R4551 VSS.n511 VSS.n509 15.5561
R4552 VSS.n509 VSS.n507 15.5561
R4553 VSS.n507 VSS.n505 15.5561
R4554 VSS.n505 VSS.n504 15.5561
R4555 VSS.n504 VSS.n502 15.5561
R4556 VSS.n502 VSS.n577 193.181
R4557 VSS.n571 VSS.n574 193.181
R4558 VSS.n574 VSS.n685 193.181
R4559 VSS.n499 VSS.n500 9.77528
R4560 VSS.n500 VSS.n493 9.77528
R4561 VSS.n499 VSS.t8 4.30565
R4562 VSS.n496 VSS.n499 13.0421
R4563 VSS.n498 VSS.n496 15.2141
R4564 VSS.n497 VSS.n498 0.1967
R4565 VSS.n498 VSS.t21 19.8518
R4566 VSS.n486 VSS.n487 16.0346
R4567 VSS.n496 VSS.n495 0.303761
R4568 VSS.n495 VSS.t32 4.30565
R4569 VSS.n495 VSS.n490 9.77528
R4570 VSS.n490 VSS.n494 9.77528
R4571 VSS.n494 VSS.t33 4.30565
R4572 VSS.n493 VSS.n494 13.3909
R4573 VSS.n493 VSS.t9 4.30565
R4574 VSS.n492 VSS.n489 821.625
R4575 VSS.n497 VSS.n486 23.8121
R4576 VSS.n388 VSS.n384 4.5005
R4577 VSS.n387 VSS.n393 4.5005
R4578 VSS.n384 VSS.n387 0.1445
R4579 VSS.n388 VSS.n393 0.1445
R4580 VSS.n381 VSS.n388 5.24633
R4581 VSS.n392 VSS.n381 5.07533
R4582 VSS.n389 VSS.n374 4.5005
R4583 VSS.n390 VSS.n391 4.5005
R4584 VSS.n389 VSS.n391 0.1445
R4585 VSS.n392 VSS.n389 0.1715
R4586 VSS.n23 VSS.n392 9.48839
R4587 VSS.n391 VSS.n378 5.24633
R4588 VSS.n378 VSS.n393 5.24633
R4589 VSS.n374 VSS.n390 0.1445
R4590 VSS.n386 VSS.n383 15.5561
R4591 VSS.n380 VSS.n383 73.5005
R4592 VSS.n375 VSS.n373 15.5561
R4593 VSS.n373 VSS.n380 73.5005
R4594 VSS.n375 VSS.n377 73.5005
R4595 VSS.n377 VSS.n386 73.5005
R4596 VSS.n371 VSS.n370 1.59299
R4597 VSS.n371 VSS.n372 7.22987
R4598 VSS.n22 VSS.n371 15.0182
R4599 VSS.n364 VSS.n360 4.5005
R4600 VSS.n363 VSS.n369 4.5005
R4601 VSS.n360 VSS.n363 0.1445
R4602 VSS.n364 VSS.n369 0.1445
R4603 VSS.n357 VSS.n364 5.63665
R4604 VSS.n368 VSS.n357 5.46565
R4605 VSS.n365 VSS.n350 4.5005
R4606 VSS.n366 VSS.n367 4.5005
R4607 VSS.n365 VSS.n367 0.1445
R4608 VSS.n368 VSS.n365 0.1715
R4609 VSS.n20 VSS.n368 9.48839
R4610 VSS.n367 VSS.n354 5.63665
R4611 VSS.n354 VSS.n369 5.63665
R4612 VSS.n350 VSS.n366 0.1445
R4613 VSS.n362 VSS.n359 15.5561
R4614 VSS.n356 VSS.n359 112.293
R4615 VSS.n351 VSS.n349 15.5561
R4616 VSS.n349 VSS.n356 112.293
R4617 VSS.n351 VSS.n353 112.293
R4618 VSS.n353 VSS.n362 112.293
R4619 VSS.n343 VSS.n339 4.5005
R4620 VSS.n342 VSS.n348 4.5005
R4621 VSS.n339 VSS.n342 0.1445
R4622 VSS.n343 VSS.n348 0.1445
R4623 VSS.n336 VSS.n343 5.24633
R4624 VSS.n347 VSS.n336 5.07533
R4625 VSS.n344 VSS.n329 4.5005
R4626 VSS.n346 VSS.n345 4.5005
R4627 VSS.n344 VSS.n346 0.1445
R4628 VSS.n347 VSS.n344 0.1715
R4629 VSS.n18 VSS.n347 9.48839
R4630 VSS.n346 VSS.n333 5.24633
R4631 VSS.n333 VSS.n348 5.24633
R4632 VSS.n345 VSS.n329 0.1445
R4633 VSS.n341 VSS.n338 15.5561
R4634 VSS.n335 VSS.n338 73.5005
R4635 VSS.n330 VSS.n328 15.5561
R4636 VSS.n328 VSS.n335 73.5005
R4637 VSS.n330 VSS.n332 73.5005
R4638 VSS.n332 VSS.n341 73.5005
R4639 VSS.n322 VSS.n318 4.5005
R4640 VSS.n321 VSS.n327 4.5005
R4641 VSS.n318 VSS.n321 0.1445
R4642 VSS.n322 VSS.n327 0.1445
R4643 VSS.n315 VSS.n322 5.63665
R4644 VSS.n326 VSS.n315 5.46565
R4645 VSS.n323 VSS.n308 4.5005
R4646 VSS.n325 VSS.n324 4.5005
R4647 VSS.n323 VSS.n325 0.1445
R4648 VSS.n326 VSS.n323 0.1715
R4649 VSS.n19 VSS.n326 9.48839
R4650 VSS.n325 VSS.n312 5.63665
R4651 VSS.n312 VSS.n327 5.63665
R4652 VSS.n324 VSS.n308 0.1445
R4653 VSS.n320 VSS.n317 15.5561
R4654 VSS.n314 VSS.n317 112.293
R4655 VSS.n309 VSS.n307 15.5561
R4656 VSS.n307 VSS.n314 112.293
R4657 VSS.n309 VSS.n311 112.293
R4658 VSS.n311 VSS.n320 112.293
R4659 VSS.n301 VSS.n297 4.5005
R4660 VSS.n300 VSS.n306 4.5005
R4661 VSS.n297 VSS.n300 0.1445
R4662 VSS.n301 VSS.n306 0.1445
R4663 VSS.n294 VSS.n301 5.63665
R4664 VSS.n305 VSS.n294 5.46565
R4665 VSS.n302 VSS.n287 4.5005
R4666 VSS.n304 VSS.n303 4.5005
R4667 VSS.n302 VSS.n304 0.1445
R4668 VSS.n305 VSS.n302 0.1715
R4669 VSS.n17 VSS.n305 9.48839
R4670 VSS.n304 VSS.n291 5.63665
R4671 VSS.n291 VSS.n306 5.63665
R4672 VSS.n303 VSS.n287 0.1445
R4673 VSS.n299 VSS.n296 15.5561
R4674 VSS.n293 VSS.n296 112.293
R4675 VSS.n288 VSS.n286 15.5561
R4676 VSS.n286 VSS.n293 112.293
R4677 VSS.n288 VSS.n290 112.293
R4678 VSS.n290 VSS.n299 112.293
R4679 VSS.n268 VSS.n246 4.5005
R4680 VSS.n269 VSS.n267 4.5005
R4681 VSS.n264 VSS.n270 4.5005
R4682 VSS.n271 VSS.n261 4.5005
R4683 VSS.n272 VSS.n258 4.5005
R4684 VSS.n255 VSS.n273 4.5005
R4685 VSS.n274 VSS.n252 4.5005
R4686 VSS.n285 VSS.n249 4.5005
R4687 VSS.n267 VSS.n264 0.1445
R4688 VSS.n261 VSS.n264 0.1445
R4689 VSS.n261 VSS.n258 0.1445
R4690 VSS.n258 VSS.n255 0.1445
R4691 VSS.n252 VSS.n255 0.1445
R4692 VSS.n252 VSS.n249 0.1445
R4693 VSS.n249 VSS.n246 0.1445
R4694 VSS.n270 VSS.n269 0.1445
R4695 VSS.n271 VSS.n270 0.1445
R4696 VSS.n272 VSS.n271 0.1445
R4697 VSS.n273 VSS.n272 0.1445
R4698 VSS.n274 VSS.n273 0.1445
R4699 VSS.n285 VSS.n274 0.1445
R4700 VSS.n268 VSS.n285 0.1445
R4701 VSS.n243 VSS.n268 5.16141
R4702 VSS.n284 VSS.n243 5.02641
R4703 VSS.n275 VSS.n224 4.5005
R4704 VSS.n237 VSS.n276 4.5005
R4705 VSS.n235 VSS.n277 4.5005
R4706 VSS.n278 VSS.n233 4.5005
R4707 VSS.n231 VSS.n279 4.5005
R4708 VSS.n229 VSS.n280 4.5005
R4709 VSS.n281 VSS.n227 4.5005
R4710 VSS.n283 VSS.n282 4.5005
R4711 VSS.n277 VSS.n276 0.1445
R4712 VSS.n278 VSS.n277 0.1445
R4713 VSS.n279 VSS.n278 0.1445
R4714 VSS.n280 VSS.n279 0.1445
R4715 VSS.n281 VSS.n280 0.1445
R4716 VSS.n283 VSS.n281 0.1445
R4717 VSS.n275 VSS.n283 0.1445
R4718 VSS.n284 VSS.n275 0.1355
R4719 VSS.n276 VSS.n240 5.16141
R4720 VSS.n240 VSS.n269 5.16141
R4721 VSS.n235 VSS.n237 0.1445
R4722 VSS.n233 VSS.n235 0.1445
R4723 VSS.n233 VSS.n231 0.1445
R4724 VSS.n229 VSS.n231 0.1445
R4725 VSS.n227 VSS.n229 0.1445
R4726 VSS.n227 VSS.n282 0.1445
R4727 VSS.n282 VSS.n224 0.1445
R4728 VSS.n266 VSS.n263 15.5561
R4729 VSS.n263 VSS.n260 15.5561
R4730 VSS.n260 VSS.n257 15.5561
R4731 VSS.n257 VSS.n254 15.5561
R4732 VSS.n254 VSS.n251 15.5561
R4733 VSS.n251 VSS.n248 15.5561
R4734 VSS.n248 VSS.n245 15.5561
R4735 VSS.n242 VSS.n245 64.7505
R4736 VSS.n236 VSS.n234 15.5561
R4737 VSS.n234 VSS.n232 15.5561
R4738 VSS.n232 VSS.n230 15.5561
R4739 VSS.n230 VSS.n228 15.5561
R4740 VSS.n228 VSS.n226 15.5561
R4741 VSS.n226 VSS.n225 15.5561
R4742 VSS.n225 VSS.n223 15.5561
R4743 VSS.n223 VSS.n242 64.7505
R4744 VSS.n236 VSS.n239 64.7505
R4745 VSS.n239 VSS.n266 64.7505
R4746 VSS.n217 VSS.n213 4.5005
R4747 VSS.n216 VSS.n222 4.5005
R4748 VSS.n213 VSS.n216 0.1445
R4749 VSS.n217 VSS.n222 0.1445
R4750 VSS.n210 VSS.n217 5.63665
R4751 VSS.n221 VSS.n210 5.46565
R4752 VSS.n218 VSS.n203 4.5005
R4753 VSS.n220 VSS.n219 4.5005
R4754 VSS.n218 VSS.n220 0.1445
R4755 VSS.n221 VSS.n218 0.1715
R4756 VSS.n16 VSS.n221 9.48839
R4757 VSS.n220 VSS.n207 5.63665
R4758 VSS.n207 VSS.n222 5.63665
R4759 VSS.n219 VSS.n203 0.1445
R4760 VSS.n215 VSS.n212 15.5561
R4761 VSS.n209 VSS.n212 112.293
R4762 VSS.n204 VSS.n202 15.5561
R4763 VSS.n202 VSS.n209 112.293
R4764 VSS.n204 VSS.n206 112.293
R4765 VSS.n206 VSS.n215 112.293
R4766 VSS.n28 VSS.n152 0.1445
R4767 VSS.n30 VSS.n28 0.1445
R4768 VSS.n30 VSS.n32 0.1445
R4769 VSS.n32 VSS.n34 0.1445
R4770 VSS.n34 VSS.n36 0.1445
R4771 VSS.n36 VSS.n38 0.1445
R4772 VSS.n38 VSS.n40 0.1445
R4773 VSS.n42 VSS.n40 0.1445
R4774 VSS.n42 VSS.n44 0.1445
R4775 VSS.n44 VSS.n46 0.1445
R4776 VSS.n46 VSS.n48 0.1445
R4777 VSS.n48 VSS.n50 0.1445
R4778 VSS.n50 VSS.n52 0.1445
R4779 VSS.n52 VSS.n54 0.1445
R4780 VSS.n54 VSS.n56 0.1445
R4781 VSS.n56 VSS.n58 0.1445
R4782 VSS.n58 VSS.n60 0.1445
R4783 VSS.n60 VSS.n62 0.1445
R4784 VSS.n62 VSS.n64 0.1445
R4785 VSS.n64 VSS.n66 0.1445
R4786 VSS.n66 VSS.n68 0.1445
R4787 VSS.n68 VSS.n70 0.1445
R4788 VSS.n70 VSS.n72 0.1445
R4789 VSS.n72 VSS.n25 0.1445
R4790 VSS.n15 VSS.n14 2.2505
R4791 VSS.n1 VSS.n0 5.76815
R4792 VSS.n2 VSS.n1 0.82715
R4793 VSS.n3 VSS.n2 0.82715
R4794 VSS.n14 VSS.n3 2.21495
R4795 VSS.n14 VSS.n12 0.7304
R4796 VSS.n12 VSS.n10 0.2714
R4797 VSS.n10 VSS.n8 0.5927
R4798 VSS.n8 VSS.n7 1.11425
R4799 VSS.n7 VSS.n5 4.1918
R4800 VSS.n5 VSS.n4 13.5826
R4801 VSS.n12 VSS.n13 13.4573
R4802 VSS.n13 VSS.t23 8.54014
R4803 VSS.n13 VSS.t15 7.16854
R4804 VSS.n10 VSS.n11 12.9463
R4805 VSS.n11 VSS.t25 8.87799
R4806 VSS.n11 VSS.t13 8.58639
R4807 VSS.n8 VSS.n9 13.2471
R4808 VSS.n9 VSS.t11 8.00985
R4809 VSS.n9 VSS.t4 8.46705
R4810 VSS.n7 VSS.t48 27.143
R4811 VSS.n5 VSS.n6 13.7178
R4812 VSS.n6 VSS.t19 8.54014
R4813 VSS.n6 VSS.t37 7.16854
R4814 VSS.n4 VSS.t1 7.75389
R4815 VSS.n4 VSS.t6 7.88169
R4816 VSS.n3 VSS.t54 27.143
R4817 VSS.n2 VSS.t52 19.5408
R4818 VSS.n1 VSS.t50 19.5408
R4819 VSS.n0 VSS.t28 24.9391
R4820 VSS.n0 VSS.t80 13.7374
R4821 a_28055_3556.t0 a_28055_3556.n0 7.74572
R4822 a_28055_3556.n0 a_28055_3556.n2 15.6427
R4823 a_28055_3556.n2 a_28055_3556.n1 11.8698
R4824 a_28055_3556.n2 a_28055_3556.n3 10.2552
R4825 a_28055_3556.n3 a_28055_3556.t4 8.60353
R4826 a_28055_3556.n3 a_28055_3556.t5 5.93593
R4827 a_28055_3556.n1 a_28055_3556.t3 6.52128
R4828 a_28055_3556.n1 a_28055_3556.t2 7.08108
R4829 a_28055_3556.n0 a_28055_3556.t1 8.20292
R4830 a_18233_3337.t3 a_18233_3337.n0 8.38076
R4831 a_18233_3337.n1 a_18233_3337.t5 35.2802
R4832 a_18233_3337.n0 a_18233_3337.n1 14.076
R4833 a_18233_3337.n1 a_18233_3337.n5 22.6823
R4834 a_18233_3337.n5 a_18233_3337.t4 29.8432
R4835 a_18233_3337.n5 a_18233_3337.n3 1.34458
R4836 a_18233_3337.n3 a_18233_3337.n2 11.1937
R4837 a_18233_3337.n3 a_18233_3337.n4 10.8492
R4838 a_18233_3337.n4 a_18233_3337.t2 38.6921
R4839 a_18233_3337.n4 a_18233_3337.t0 37.3205
R4840 a_18233_3337.n2 a_18233_3337.t6 51.161
R4841 a_18233_3337.n2 a_18233_3337.t7 50.7038
R4842 a_18233_3337.n0 a_18233_3337.t1 7.64096
R4843 a_25710_9686.t1 a_25710_9686.n0 7.55729
R4844 a_25710_9686.n0 a_25710_9686.n1 33.2519
R4845 a_25710_9686.n1 a_25710_9686.t3 6.64919
R4846 a_25710_9686.n1 a_25710_9686.t0 7.53839
R4847 a_25710_9686.n0 a_25710_9686.t2 7.67609
R4848 a_25442_9686.t0 a_25442_9686.n0 8.15716
R4849 a_25442_9686.n0 a_25442_9686.n2 18.0585
R4850 a_25442_9686.n2 a_25442_9686.n1 14.8943
R4851 a_25442_9686.n2 a_25442_9686.n4 24.638
R4852 a_25442_9686.n4 a_25442_9686.n3 12.0665
R4853 a_25442_9686.n4 a_25442_9686.n5 11.0387
R4854 a_25442_9686.n5 a_25442_9686.t4 13.4886
R4855 a_25442_9686.n5 a_25442_9686.t2 10.8217
R4856 a_25442_9686.n3 a_25442_9686.t6 15.6519
R4857 a_25442_9686.n3 a_25442_9686.t7 14.8585
R4858 a_25442_9686.n1 a_25442_9686.t5 8.43624
R4859 a_25442_9686.n1 a_25442_9686.t3 6.68844
R4860 a_25442_9686.n0 a_25442_9686.t1 7.44436
R4861 a_25212_9686.t5 a_25212_9686.n0 8.31654
R4862 a_25212_9686.n0 a_25212_9686.n4 37.2185
R4863 a_25212_9686.n4 a_25212_9686.n2 0.598526
R4864 a_25212_9686.n2 a_25212_9686.n1 20.0279
R4865 a_25212_9686.n4 a_25212_9686.n5 11.2994
R4866 a_25212_9686.n5 a_25212_9686.t4 40.9215
R4867 a_25212_9686.n5 a_25212_9686.t2 39.5769
R4868 a_25212_9686.n2 a_25212_9686.n3 11.0326
R4869 a_25212_9686.n3 a_25212_9686.t6 54.6251
R4870 a_25212_9686.n3 a_25212_9686.t7 54.1769
R4871 a_25212_9686.n1 a_25212_9686.t1 8.30015
R4872 a_25212_9686.n1 a_25212_9686.t0 6.55235
R4873 a_25212_9686.n0 a_25212_9686.t3 6.97194
R4874 a_3623_3336.t0 a_3623_3336.n0 40.8653
R4875 a_3623_3336.n0 a_3623_3336.t1 30.0843
R4876 a_3623_3336.n0 a_3623_3336.t2 72.6523
R4877 EAOUT.t3 EAOUT.n0 7.54912
R4878 EAOUT.n1 EAOUT.n0 6.87603
R4879 EAOUT.n2 EAOUT.n3 4.5005
R4880 EAOUT.n617 EAOUT.n1 4.5005
R4881 EAOUT.n1 EAOUT.n3 0.148878
R4882 EAOUT.n617 EAOUT.t4 24.6304
R4883 EAOUT.n2 EAOUT.n617 0.142605
R4884 EAOUT.n613 EAOUT.n2 4.19497
R4885 EAOUT.n613 EAOUT.n91 11.2867
R4886 EAOUT EAOUT.n616 0.0347
R4887 EAOUT.n616 EAOUT.n615 4.9271
R4888 EAOUT.n615 EAOUT.n613 13.6067
R4889 EAOUT.n616 EAOUT.t6 94.2819
R4890 EAOUT.n615 EAOUT.n614 25.5131
R4891 EAOUT.n614 EAOUT.t1 6.5131
R4892 EAOUT.n614 EAOUT.t0 7.4023
R4893 EAOUT.n4 EAOUT.n61 12.5005
R4894 EAOUT.n5 EAOUT.n62 12.5005
R4895 EAOUT.n6 EAOUT.n63 12.5005
R4896 EAOUT.n7 EAOUT.n60 12.5005
R4897 EAOUT.n8 EAOUT.n59 12.5005
R4898 EAOUT.n9 EAOUT.n65 12.5005
R4899 EAOUT.n10 EAOUT.n66 12.5005
R4900 EAOUT.n11 EAOUT.n58 12.5005
R4901 EAOUT.n12 EAOUT.n67 12.5005
R4902 EAOUT.n13 EAOUT.n68 12.5005
R4903 EAOUT.n14 EAOUT.n57 12.5005
R4904 EAOUT.n15 EAOUT.n56 12.5005
R4905 EAOUT.n16 EAOUT.n70 12.5005
R4906 EAOUT.n17 EAOUT.n71 12.5005
R4907 EAOUT.n18 EAOUT.n55 12.5005
R4908 EAOUT.n19 EAOUT.n54 12.5005
R4909 EAOUT.n20 EAOUT.n73 12.5005
R4910 EAOUT.n21 EAOUT.n53 12.5005
R4911 EAOUT.n22 EAOUT.n52 12.5005
R4912 EAOUT.n23 EAOUT.n75 12.5005
R4913 EAOUT.n24 EAOUT.n76 12.5005
R4914 EAOUT.n25 EAOUT.n51 12.5005
R4915 EAOUT.n26 EAOUT.n50 12.5005
R4916 EAOUT.n27 EAOUT.n78 12.5005
R4917 EAOUT.n28 EAOUT.n49 12.5005
R4918 EAOUT.n29 EAOUT.n48 12.5005
R4919 EAOUT.n30 EAOUT.n80 12.5005
R4920 EAOUT.n31 EAOUT.n81 12.5005
R4921 EAOUT.n32 EAOUT.n47 12.5005
R4922 EAOUT.n33 EAOUT.n46 12.5005
R4923 EAOUT.n34 EAOUT.n83 12.5005
R4924 EAOUT.n35 EAOUT.n84 12.5005
R4925 EAOUT.n36 EAOUT.n45 12.5005
R4926 EAOUT.n37 EAOUT.n85 12.5005
R4927 EAOUT.n38 EAOUT.n86 12.5005
R4928 EAOUT.n39 EAOUT.n44 12.5005
R4929 EAOUT.n40 EAOUT.n43 12.5005
R4930 EAOUT.n41 EAOUT.n88 12.5005
R4931 EAOUT.n42 EAOUT.n89 12.5005
R4932 EAOUT.n91 EAOUT.n42 0.1445
R4933 EAOUT.n42 EAOUT.n41 0.1445
R4934 EAOUT.n41 EAOUT.n40 0.1445
R4935 EAOUT.n40 EAOUT.n39 0.1445
R4936 EAOUT.n39 EAOUT.n38 0.1445
R4937 EAOUT.n38 EAOUT.n37 0.1445
R4938 EAOUT.n37 EAOUT.n36 0.1445
R4939 EAOUT.n36 EAOUT.n35 0.1445
R4940 EAOUT.n35 EAOUT.n34 0.1445
R4941 EAOUT.n34 EAOUT.n33 0.1445
R4942 EAOUT.n33 EAOUT.n32 0.1445
R4943 EAOUT.n32 EAOUT.n31 0.1445
R4944 EAOUT.n31 EAOUT.n30 0.1445
R4945 EAOUT.n30 EAOUT.n29 0.1445
R4946 EAOUT.n29 EAOUT.n28 0.1445
R4947 EAOUT.n28 EAOUT.n27 0.1445
R4948 EAOUT.n27 EAOUT.n26 0.1445
R4949 EAOUT.n26 EAOUT.n25 0.1445
R4950 EAOUT.n25 EAOUT.n24 0.1445
R4951 EAOUT.n24 EAOUT.n23 0.1445
R4952 EAOUT.n23 EAOUT.n22 0.1445
R4953 EAOUT.n22 EAOUT.n21 0.1445
R4954 EAOUT.n21 EAOUT.n20 0.1445
R4955 EAOUT.n20 EAOUT.n19 0.1445
R4956 EAOUT.n19 EAOUT.n18 0.1445
R4957 EAOUT.n18 EAOUT.n17 0.1445
R4958 EAOUT.n17 EAOUT.n16 0.1445
R4959 EAOUT.n16 EAOUT.n15 0.1445
R4960 EAOUT.n15 EAOUT.n14 0.1445
R4961 EAOUT.n14 EAOUT.n13 0.1445
R4962 EAOUT.n13 EAOUT.n12 0.1445
R4963 EAOUT.n12 EAOUT.n11 0.1445
R4964 EAOUT.n11 EAOUT.n10 0.1445
R4965 EAOUT.n10 EAOUT.n9 0.1445
R4966 EAOUT.n9 EAOUT.n8 0.1445
R4967 EAOUT.n8 EAOUT.n7 0.1445
R4968 EAOUT.n7 EAOUT.n6 0.1445
R4969 EAOUT.n6 EAOUT.n5 0.1445
R4970 EAOUT.n5 EAOUT.n4 0.1445
R4971 EAOUT.n4 EAOUT.n612 5.9063
R4972 EAOUT.n612 EAOUT.n525 1.1147
R4973 EAOUT.n525 EAOUT.n438 1.1147
R4974 EAOUT.n438 EAOUT.n351 1.1147
R4975 EAOUT.n351 EAOUT.n264 1.1147
R4976 EAOUT.n526 EAOUT.n583 12.5005
R4977 EAOUT.n527 EAOUT.n584 12.5005
R4978 EAOUT.n528 EAOUT.n585 12.5005
R4979 EAOUT.n529 EAOUT.n582 12.5005
R4980 EAOUT.n530 EAOUT.n581 12.5005
R4981 EAOUT.n531 EAOUT.n587 12.5005
R4982 EAOUT.n532 EAOUT.n588 12.5005
R4983 EAOUT.n533 EAOUT.n580 12.5005
R4984 EAOUT.n534 EAOUT.n589 12.5005
R4985 EAOUT.n535 EAOUT.n590 12.5005
R4986 EAOUT.n536 EAOUT.n579 12.5005
R4987 EAOUT.n537 EAOUT.n578 12.5005
R4988 EAOUT.n538 EAOUT.n592 12.5005
R4989 EAOUT.n539 EAOUT.n593 12.5005
R4990 EAOUT.n540 EAOUT.n577 12.5005
R4991 EAOUT.n541 EAOUT.n576 12.5005
R4992 EAOUT.n542 EAOUT.n595 12.5005
R4993 EAOUT.n543 EAOUT.n575 12.5005
R4994 EAOUT.n544 EAOUT.n574 12.5005
R4995 EAOUT.n545 EAOUT.n597 12.5005
R4996 EAOUT.n546 EAOUT.n598 12.5005
R4997 EAOUT.n547 EAOUT.n573 12.5005
R4998 EAOUT.n548 EAOUT.n572 12.5005
R4999 EAOUT.n549 EAOUT.n600 12.5005
R5000 EAOUT.n550 EAOUT.n571 12.5005
R5001 EAOUT.n551 EAOUT.n570 12.5005
R5002 EAOUT.n552 EAOUT.n602 12.5005
R5003 EAOUT.n553 EAOUT.n603 12.5005
R5004 EAOUT.n554 EAOUT.n569 12.5005
R5005 EAOUT.n555 EAOUT.n568 12.5005
R5006 EAOUT.n556 EAOUT.n605 12.5005
R5007 EAOUT.n557 EAOUT.n606 12.5005
R5008 EAOUT.n558 EAOUT.n567 12.5005
R5009 EAOUT.n559 EAOUT.n607 12.5005
R5010 EAOUT.n560 EAOUT.n608 12.5005
R5011 EAOUT.n561 EAOUT.n566 12.5005
R5012 EAOUT.n562 EAOUT.n565 12.5005
R5013 EAOUT.n563 EAOUT.n610 12.5005
R5014 EAOUT.n564 EAOUT.n611 2.06191
R5015 EAOUT.n563 EAOUT.n564 5.39444
R5016 EAOUT.n562 EAOUT.n563 0.1445
R5017 EAOUT.n561 EAOUT.n562 0.1445
R5018 EAOUT.n560 EAOUT.n561 0.1445
R5019 EAOUT.n559 EAOUT.n560 0.1445
R5020 EAOUT.n558 EAOUT.n559 0.1445
R5021 EAOUT.n557 EAOUT.n558 0.1445
R5022 EAOUT.n556 EAOUT.n557 0.1445
R5023 EAOUT.n555 EAOUT.n556 0.1445
R5024 EAOUT.n554 EAOUT.n555 0.1445
R5025 EAOUT.n553 EAOUT.n554 0.1445
R5026 EAOUT.n552 EAOUT.n553 0.1445
R5027 EAOUT.n551 EAOUT.n552 0.1445
R5028 EAOUT.n550 EAOUT.n551 0.1445
R5029 EAOUT.n549 EAOUT.n550 0.1445
R5030 EAOUT.n548 EAOUT.n549 0.1445
R5031 EAOUT.n547 EAOUT.n548 0.1445
R5032 EAOUT.n546 EAOUT.n547 0.1445
R5033 EAOUT.n545 EAOUT.n546 0.1445
R5034 EAOUT.n544 EAOUT.n545 0.1445
R5035 EAOUT.n543 EAOUT.n544 0.1445
R5036 EAOUT.n542 EAOUT.n543 0.1445
R5037 EAOUT.n541 EAOUT.n542 0.1445
R5038 EAOUT.n540 EAOUT.n541 0.1445
R5039 EAOUT.n539 EAOUT.n540 0.1445
R5040 EAOUT.n538 EAOUT.n539 0.1445
R5041 EAOUT.n537 EAOUT.n538 0.1445
R5042 EAOUT.n536 EAOUT.n537 0.1445
R5043 EAOUT.n535 EAOUT.n536 0.1445
R5044 EAOUT.n534 EAOUT.n535 0.1445
R5045 EAOUT.n533 EAOUT.n534 0.1445
R5046 EAOUT.n532 EAOUT.n533 0.1445
R5047 EAOUT.n531 EAOUT.n532 0.1445
R5048 EAOUT.n530 EAOUT.n531 0.1445
R5049 EAOUT.n529 EAOUT.n530 0.1445
R5050 EAOUT.n528 EAOUT.n529 0.1445
R5051 EAOUT.n527 EAOUT.n528 0.1445
R5052 EAOUT.n526 EAOUT.n527 0.1445
R5053 EAOUT.n612 EAOUT.n526 4.7921
R5054 EAOUT.n564 EAOUT.t66 35.6922
R5055 EAOUT.n611 EAOUT.t65 30.395
R5056 EAOUT.n611 EAOUT.n610 8.1765
R5057 EAOUT.n610 EAOUT.t64 30.395
R5058 EAOUT.n610 EAOUT.n565 5.8405
R5059 EAOUT.n565 EAOUT.n609 2.3365
R5060 EAOUT.n609 EAOUT.t63 30.395
R5061 EAOUT.n566 EAOUT.n609 1.3145
R5062 EAOUT.n566 EAOUT.n608 6.8625
R5063 EAOUT.n608 EAOUT.t62 30.395
R5064 EAOUT.n608 EAOUT.n607 8.1765
R5065 EAOUT.n607 EAOUT.t61 30.395
R5066 EAOUT.n607 EAOUT.n567 3.9425
R5067 EAOUT.n567 EAOUT.n606 4.2345
R5068 EAOUT.n606 EAOUT.t60 30.395
R5069 EAOUT.n606 EAOUT.n605 8.1765
R5070 EAOUT.n605 EAOUT.t59 30.395
R5071 EAOUT.n605 EAOUT.n568 6.5705
R5072 EAOUT.n568 EAOUT.n604 1.6065
R5073 EAOUT.n604 EAOUT.t58 30.395
R5074 EAOUT.n604 EAOUT.n569 2.0445
R5075 EAOUT.n569 EAOUT.n603 6.1325
R5076 EAOUT.n603 EAOUT.t57 30.395
R5077 EAOUT.n603 EAOUT.n602 8.1765
R5078 EAOUT.n602 EAOUT.t56 30.395
R5079 EAOUT.n602 EAOUT.n570 4.6725
R5080 EAOUT.n570 EAOUT.n601 3.5045
R5081 EAOUT.n601 EAOUT.t55 30.395
R5082 EAOUT.n571 EAOUT.n601 0.1465
R5083 EAOUT.n571 EAOUT.n600 8.0305
R5084 EAOUT.n600 EAOUT.t54 30.395
R5085 EAOUT.n600 EAOUT.n572 7.3005
R5086 EAOUT.n572 EAOUT.n599 0.8765
R5087 EAOUT.n599 EAOUT.t53 30.395
R5088 EAOUT.n599 EAOUT.n573 2.7745
R5089 EAOUT.n573 EAOUT.n598 5.4025
R5090 EAOUT.n598 EAOUT.t52 30.395
R5091 EAOUT.n598 EAOUT.n597 8.1765
R5092 EAOUT.n597 EAOUT.t51 30.395
R5093 EAOUT.n597 EAOUT.n574 5.4025
R5094 EAOUT.n574 EAOUT.n596 2.7745
R5095 EAOUT.n596 EAOUT.t50 30.395
R5096 EAOUT.n575 EAOUT.n596 0.8765
R5097 EAOUT.n575 EAOUT.n595 7.3005
R5098 EAOUT.n595 EAOUT.t49 30.395
R5099 EAOUT.n595 EAOUT.n576 8.0305
R5100 EAOUT.n576 EAOUT.n594 0.1465
R5101 EAOUT.n594 EAOUT.t48 30.395
R5102 EAOUT.n594 EAOUT.n577 3.5045
R5103 EAOUT.n577 EAOUT.n593 4.6725
R5104 EAOUT.n593 EAOUT.t47 30.395
R5105 EAOUT.n593 EAOUT.n592 8.1765
R5106 EAOUT.n592 EAOUT.t46 30.395
R5107 EAOUT.n592 EAOUT.n578 6.1325
R5108 EAOUT.n578 EAOUT.n591 2.0445
R5109 EAOUT.n591 EAOUT.t45 30.395
R5110 EAOUT.n579 EAOUT.n591 1.6065
R5111 EAOUT.n579 EAOUT.n590 6.5705
R5112 EAOUT.n590 EAOUT.t44 30.395
R5113 EAOUT.n590 EAOUT.n589 8.1765
R5114 EAOUT.n589 EAOUT.t43 30.395
R5115 EAOUT.n589 EAOUT.n580 4.2345
R5116 EAOUT.n580 EAOUT.n588 3.9425
R5117 EAOUT.n588 EAOUT.t42 30.395
R5118 EAOUT.n588 EAOUT.n587 8.1765
R5119 EAOUT.n587 EAOUT.t41 30.395
R5120 EAOUT.n587 EAOUT.n581 6.8625
R5121 EAOUT.n581 EAOUT.n586 1.3145
R5122 EAOUT.n586 EAOUT.t40 30.395
R5123 EAOUT.n586 EAOUT.n582 2.3365
R5124 EAOUT.n582 EAOUT.n585 5.8405
R5125 EAOUT.n585 EAOUT.t39 30.395
R5126 EAOUT.n585 EAOUT.n584 8.1765
R5127 EAOUT.n584 EAOUT.t38 30.395
R5128 EAOUT.n584 EAOUT.n583 4.9645
R5129 EAOUT.n583 EAOUT.t37 33.607
R5130 EAOUT.n439 EAOUT.n496 12.5005
R5131 EAOUT.n440 EAOUT.n497 12.5005
R5132 EAOUT.n441 EAOUT.n498 12.5005
R5133 EAOUT.n442 EAOUT.n495 12.5005
R5134 EAOUT.n443 EAOUT.n494 12.5005
R5135 EAOUT.n444 EAOUT.n500 12.5005
R5136 EAOUT.n445 EAOUT.n501 12.5005
R5137 EAOUT.n446 EAOUT.n493 12.5005
R5138 EAOUT.n447 EAOUT.n502 12.5005
R5139 EAOUT.n448 EAOUT.n503 12.5005
R5140 EAOUT.n449 EAOUT.n492 12.5005
R5141 EAOUT.n450 EAOUT.n491 12.5005
R5142 EAOUT.n451 EAOUT.n505 12.5005
R5143 EAOUT.n452 EAOUT.n506 12.5005
R5144 EAOUT.n453 EAOUT.n490 12.5005
R5145 EAOUT.n454 EAOUT.n489 12.5005
R5146 EAOUT.n455 EAOUT.n508 12.5005
R5147 EAOUT.n456 EAOUT.n488 12.5005
R5148 EAOUT.n457 EAOUT.n487 12.5005
R5149 EAOUT.n458 EAOUT.n510 12.5005
R5150 EAOUT.n459 EAOUT.n511 12.5005
R5151 EAOUT.n460 EAOUT.n486 12.5005
R5152 EAOUT.n461 EAOUT.n485 12.5005
R5153 EAOUT.n462 EAOUT.n513 12.5005
R5154 EAOUT.n463 EAOUT.n484 12.5005
R5155 EAOUT.n464 EAOUT.n483 12.5005
R5156 EAOUT.n465 EAOUT.n515 12.5005
R5157 EAOUT.n466 EAOUT.n516 12.5005
R5158 EAOUT.n467 EAOUT.n482 12.5005
R5159 EAOUT.n468 EAOUT.n481 12.5005
R5160 EAOUT.n469 EAOUT.n518 12.5005
R5161 EAOUT.n470 EAOUT.n519 12.5005
R5162 EAOUT.n471 EAOUT.n480 12.5005
R5163 EAOUT.n472 EAOUT.n520 12.5005
R5164 EAOUT.n473 EAOUT.n521 12.5005
R5165 EAOUT.n474 EAOUT.n479 12.5005
R5166 EAOUT.n475 EAOUT.n478 12.5005
R5167 EAOUT.n476 EAOUT.n523 12.5005
R5168 EAOUT.n477 EAOUT.n524 2.06191
R5169 EAOUT.n476 EAOUT.n477 5.39444
R5170 EAOUT.n475 EAOUT.n476 0.1445
R5171 EAOUT.n474 EAOUT.n475 0.1445
R5172 EAOUT.n473 EAOUT.n474 0.1445
R5173 EAOUT.n472 EAOUT.n473 0.1445
R5174 EAOUT.n471 EAOUT.n472 0.1445
R5175 EAOUT.n470 EAOUT.n471 0.1445
R5176 EAOUT.n469 EAOUT.n470 0.1445
R5177 EAOUT.n468 EAOUT.n469 0.1445
R5178 EAOUT.n467 EAOUT.n468 0.1445
R5179 EAOUT.n466 EAOUT.n467 0.1445
R5180 EAOUT.n465 EAOUT.n466 0.1445
R5181 EAOUT.n464 EAOUT.n465 0.1445
R5182 EAOUT.n463 EAOUT.n464 0.1445
R5183 EAOUT.n462 EAOUT.n463 0.1445
R5184 EAOUT.n461 EAOUT.n462 0.1445
R5185 EAOUT.n460 EAOUT.n461 0.1445
R5186 EAOUT.n459 EAOUT.n460 0.1445
R5187 EAOUT.n458 EAOUT.n459 0.1445
R5188 EAOUT.n457 EAOUT.n458 0.1445
R5189 EAOUT.n456 EAOUT.n457 0.1445
R5190 EAOUT.n455 EAOUT.n456 0.1445
R5191 EAOUT.n454 EAOUT.n455 0.1445
R5192 EAOUT.n453 EAOUT.n454 0.1445
R5193 EAOUT.n452 EAOUT.n453 0.1445
R5194 EAOUT.n451 EAOUT.n452 0.1445
R5195 EAOUT.n450 EAOUT.n451 0.1445
R5196 EAOUT.n449 EAOUT.n450 0.1445
R5197 EAOUT.n448 EAOUT.n449 0.1445
R5198 EAOUT.n447 EAOUT.n448 0.1445
R5199 EAOUT.n446 EAOUT.n447 0.1445
R5200 EAOUT.n445 EAOUT.n446 0.1445
R5201 EAOUT.n444 EAOUT.n445 0.1445
R5202 EAOUT.n443 EAOUT.n444 0.1445
R5203 EAOUT.n442 EAOUT.n443 0.1445
R5204 EAOUT.n441 EAOUT.n442 0.1445
R5205 EAOUT.n440 EAOUT.n441 0.1445
R5206 EAOUT.n439 EAOUT.n440 0.1445
R5207 EAOUT.n525 EAOUT.n439 4.7921
R5208 EAOUT.n477 EAOUT.t96 35.6922
R5209 EAOUT.n524 EAOUT.t95 30.395
R5210 EAOUT.n524 EAOUT.n523 8.1765
R5211 EAOUT.n523 EAOUT.t94 30.395
R5212 EAOUT.n523 EAOUT.n478 5.8405
R5213 EAOUT.n478 EAOUT.n522 2.3365
R5214 EAOUT.n522 EAOUT.t93 30.395
R5215 EAOUT.n479 EAOUT.n522 1.3145
R5216 EAOUT.n479 EAOUT.n521 6.8625
R5217 EAOUT.n521 EAOUT.t92 30.395
R5218 EAOUT.n521 EAOUT.n520 8.1765
R5219 EAOUT.n520 EAOUT.t91 30.395
R5220 EAOUT.n520 EAOUT.n480 3.9425
R5221 EAOUT.n480 EAOUT.n519 4.2345
R5222 EAOUT.n519 EAOUT.t90 30.395
R5223 EAOUT.n519 EAOUT.n518 8.1765
R5224 EAOUT.n518 EAOUT.t89 30.395
R5225 EAOUT.n518 EAOUT.n481 6.5705
R5226 EAOUT.n481 EAOUT.n517 1.6065
R5227 EAOUT.n517 EAOUT.t88 30.395
R5228 EAOUT.n517 EAOUT.n482 2.0445
R5229 EAOUT.n482 EAOUT.n516 6.1325
R5230 EAOUT.n516 EAOUT.t87 30.395
R5231 EAOUT.n516 EAOUT.n515 8.1765
R5232 EAOUT.n515 EAOUT.t86 30.395
R5233 EAOUT.n515 EAOUT.n483 4.6725
R5234 EAOUT.n483 EAOUT.n514 3.5045
R5235 EAOUT.n514 EAOUT.t85 30.395
R5236 EAOUT.n484 EAOUT.n514 0.1465
R5237 EAOUT.n484 EAOUT.n513 8.0305
R5238 EAOUT.n513 EAOUT.t84 30.395
R5239 EAOUT.n513 EAOUT.n485 7.3005
R5240 EAOUT.n485 EAOUT.n512 0.8765
R5241 EAOUT.n512 EAOUT.t83 30.395
R5242 EAOUT.n512 EAOUT.n486 2.7745
R5243 EAOUT.n486 EAOUT.n511 5.4025
R5244 EAOUT.n511 EAOUT.t82 30.395
R5245 EAOUT.n511 EAOUT.n510 8.1765
R5246 EAOUT.n510 EAOUT.t81 30.395
R5247 EAOUT.n510 EAOUT.n487 5.4025
R5248 EAOUT.n487 EAOUT.n509 2.7745
R5249 EAOUT.n509 EAOUT.t80 30.395
R5250 EAOUT.n488 EAOUT.n509 0.8765
R5251 EAOUT.n488 EAOUT.n508 7.3005
R5252 EAOUT.n508 EAOUT.t79 30.395
R5253 EAOUT.n508 EAOUT.n489 8.0305
R5254 EAOUT.n489 EAOUT.n507 0.1465
R5255 EAOUT.n507 EAOUT.t78 30.395
R5256 EAOUT.n507 EAOUT.n490 3.5045
R5257 EAOUT.n490 EAOUT.n506 4.6725
R5258 EAOUT.n506 EAOUT.t77 30.395
R5259 EAOUT.n506 EAOUT.n505 8.1765
R5260 EAOUT.n505 EAOUT.t76 30.395
R5261 EAOUT.n505 EAOUT.n491 6.1325
R5262 EAOUT.n491 EAOUT.n504 2.0445
R5263 EAOUT.n504 EAOUT.t75 30.395
R5264 EAOUT.n492 EAOUT.n504 1.6065
R5265 EAOUT.n492 EAOUT.n503 6.5705
R5266 EAOUT.n503 EAOUT.t74 30.395
R5267 EAOUT.n503 EAOUT.n502 8.1765
R5268 EAOUT.n502 EAOUT.t73 30.395
R5269 EAOUT.n502 EAOUT.n493 4.2345
R5270 EAOUT.n493 EAOUT.n501 3.9425
R5271 EAOUT.n501 EAOUT.t72 30.395
R5272 EAOUT.n501 EAOUT.n500 8.1765
R5273 EAOUT.n500 EAOUT.t71 30.395
R5274 EAOUT.n500 EAOUT.n494 6.8625
R5275 EAOUT.n494 EAOUT.n499 1.3145
R5276 EAOUT.n499 EAOUT.t70 30.395
R5277 EAOUT.n499 EAOUT.n495 2.3365
R5278 EAOUT.n495 EAOUT.n498 5.8405
R5279 EAOUT.n498 EAOUT.t69 30.395
R5280 EAOUT.n498 EAOUT.n497 8.1765
R5281 EAOUT.n497 EAOUT.t68 30.395
R5282 EAOUT.n497 EAOUT.n496 4.9645
R5283 EAOUT.n496 EAOUT.t67 33.607
R5284 EAOUT.n352 EAOUT.n409 12.5005
R5285 EAOUT.n353 EAOUT.n410 12.5005
R5286 EAOUT.n354 EAOUT.n411 12.5005
R5287 EAOUT.n355 EAOUT.n408 12.5005
R5288 EAOUT.n356 EAOUT.n407 12.5005
R5289 EAOUT.n357 EAOUT.n413 12.5005
R5290 EAOUT.n358 EAOUT.n414 12.5005
R5291 EAOUT.n359 EAOUT.n406 12.5005
R5292 EAOUT.n360 EAOUT.n415 12.5005
R5293 EAOUT.n361 EAOUT.n416 12.5005
R5294 EAOUT.n362 EAOUT.n405 12.5005
R5295 EAOUT.n363 EAOUT.n404 12.5005
R5296 EAOUT.n364 EAOUT.n418 12.5005
R5297 EAOUT.n365 EAOUT.n419 12.5005
R5298 EAOUT.n366 EAOUT.n403 12.5005
R5299 EAOUT.n367 EAOUT.n402 12.5005
R5300 EAOUT.n368 EAOUT.n421 12.5005
R5301 EAOUT.n369 EAOUT.n401 12.5005
R5302 EAOUT.n370 EAOUT.n400 12.5005
R5303 EAOUT.n371 EAOUT.n423 12.5005
R5304 EAOUT.n372 EAOUT.n424 12.5005
R5305 EAOUT.n373 EAOUT.n399 12.5005
R5306 EAOUT.n374 EAOUT.n398 12.5005
R5307 EAOUT.n375 EAOUT.n426 12.5005
R5308 EAOUT.n376 EAOUT.n397 12.5005
R5309 EAOUT.n377 EAOUT.n396 12.5005
R5310 EAOUT.n378 EAOUT.n428 12.5005
R5311 EAOUT.n379 EAOUT.n429 12.5005
R5312 EAOUT.n380 EAOUT.n395 12.5005
R5313 EAOUT.n381 EAOUT.n394 12.5005
R5314 EAOUT.n382 EAOUT.n431 12.5005
R5315 EAOUT.n383 EAOUT.n432 12.5005
R5316 EAOUT.n384 EAOUT.n393 12.5005
R5317 EAOUT.n385 EAOUT.n433 12.5005
R5318 EAOUT.n386 EAOUT.n434 12.5005
R5319 EAOUT.n387 EAOUT.n392 12.5005
R5320 EAOUT.n388 EAOUT.n391 12.5005
R5321 EAOUT.n389 EAOUT.n436 12.5005
R5322 EAOUT.n390 EAOUT.n437 2.06191
R5323 EAOUT.n389 EAOUT.n390 5.39444
R5324 EAOUT.n388 EAOUT.n389 0.1445
R5325 EAOUT.n387 EAOUT.n388 0.1445
R5326 EAOUT.n386 EAOUT.n387 0.1445
R5327 EAOUT.n385 EAOUT.n386 0.1445
R5328 EAOUT.n384 EAOUT.n385 0.1445
R5329 EAOUT.n383 EAOUT.n384 0.1445
R5330 EAOUT.n382 EAOUT.n383 0.1445
R5331 EAOUT.n381 EAOUT.n382 0.1445
R5332 EAOUT.n380 EAOUT.n381 0.1445
R5333 EAOUT.n379 EAOUT.n380 0.1445
R5334 EAOUT.n378 EAOUT.n379 0.1445
R5335 EAOUT.n377 EAOUT.n378 0.1445
R5336 EAOUT.n376 EAOUT.n377 0.1445
R5337 EAOUT.n375 EAOUT.n376 0.1445
R5338 EAOUT.n374 EAOUT.n375 0.1445
R5339 EAOUT.n373 EAOUT.n374 0.1445
R5340 EAOUT.n372 EAOUT.n373 0.1445
R5341 EAOUT.n371 EAOUT.n372 0.1445
R5342 EAOUT.n370 EAOUT.n371 0.1445
R5343 EAOUT.n369 EAOUT.n370 0.1445
R5344 EAOUT.n368 EAOUT.n369 0.1445
R5345 EAOUT.n367 EAOUT.n368 0.1445
R5346 EAOUT.n366 EAOUT.n367 0.1445
R5347 EAOUT.n365 EAOUT.n366 0.1445
R5348 EAOUT.n364 EAOUT.n365 0.1445
R5349 EAOUT.n363 EAOUT.n364 0.1445
R5350 EAOUT.n362 EAOUT.n363 0.1445
R5351 EAOUT.n361 EAOUT.n362 0.1445
R5352 EAOUT.n360 EAOUT.n361 0.1445
R5353 EAOUT.n359 EAOUT.n360 0.1445
R5354 EAOUT.n358 EAOUT.n359 0.1445
R5355 EAOUT.n357 EAOUT.n358 0.1445
R5356 EAOUT.n356 EAOUT.n357 0.1445
R5357 EAOUT.n355 EAOUT.n356 0.1445
R5358 EAOUT.n354 EAOUT.n355 0.1445
R5359 EAOUT.n353 EAOUT.n354 0.1445
R5360 EAOUT.n352 EAOUT.n353 0.1445
R5361 EAOUT.n438 EAOUT.n352 4.7921
R5362 EAOUT.n390 EAOUT.t126 35.6922
R5363 EAOUT.n437 EAOUT.t125 30.395
R5364 EAOUT.n437 EAOUT.n436 8.1765
R5365 EAOUT.n436 EAOUT.t124 30.395
R5366 EAOUT.n436 EAOUT.n391 5.8405
R5367 EAOUT.n391 EAOUT.n435 2.3365
R5368 EAOUT.n435 EAOUT.t123 30.395
R5369 EAOUT.n392 EAOUT.n435 1.3145
R5370 EAOUT.n392 EAOUT.n434 6.8625
R5371 EAOUT.n434 EAOUT.t122 30.395
R5372 EAOUT.n434 EAOUT.n433 8.1765
R5373 EAOUT.n433 EAOUT.t121 30.395
R5374 EAOUT.n433 EAOUT.n393 3.9425
R5375 EAOUT.n393 EAOUT.n432 4.2345
R5376 EAOUT.n432 EAOUT.t120 30.395
R5377 EAOUT.n432 EAOUT.n431 8.1765
R5378 EAOUT.n431 EAOUT.t119 30.395
R5379 EAOUT.n431 EAOUT.n394 6.5705
R5380 EAOUT.n394 EAOUT.n430 1.6065
R5381 EAOUT.n430 EAOUT.t118 30.395
R5382 EAOUT.n430 EAOUT.n395 2.0445
R5383 EAOUT.n395 EAOUT.n429 6.1325
R5384 EAOUT.n429 EAOUT.t117 30.395
R5385 EAOUT.n429 EAOUT.n428 8.1765
R5386 EAOUT.n428 EAOUT.t116 30.395
R5387 EAOUT.n428 EAOUT.n396 4.6725
R5388 EAOUT.n396 EAOUT.n427 3.5045
R5389 EAOUT.n427 EAOUT.t115 30.395
R5390 EAOUT.n397 EAOUT.n427 0.1465
R5391 EAOUT.n397 EAOUT.n426 8.0305
R5392 EAOUT.n426 EAOUT.t114 30.395
R5393 EAOUT.n426 EAOUT.n398 7.3005
R5394 EAOUT.n398 EAOUT.n425 0.8765
R5395 EAOUT.n425 EAOUT.t113 30.395
R5396 EAOUT.n425 EAOUT.n399 2.7745
R5397 EAOUT.n399 EAOUT.n424 5.4025
R5398 EAOUT.n424 EAOUT.t112 30.395
R5399 EAOUT.n424 EAOUT.n423 8.1765
R5400 EAOUT.n423 EAOUT.t111 30.395
R5401 EAOUT.n423 EAOUT.n400 5.4025
R5402 EAOUT.n400 EAOUT.n422 2.7745
R5403 EAOUT.n422 EAOUT.t110 30.395
R5404 EAOUT.n401 EAOUT.n422 0.8765
R5405 EAOUT.n401 EAOUT.n421 7.3005
R5406 EAOUT.n421 EAOUT.t109 30.395
R5407 EAOUT.n421 EAOUT.n402 8.0305
R5408 EAOUT.n402 EAOUT.n420 0.1465
R5409 EAOUT.n420 EAOUT.t108 30.395
R5410 EAOUT.n420 EAOUT.n403 3.5045
R5411 EAOUT.n403 EAOUT.n419 4.6725
R5412 EAOUT.n419 EAOUT.t107 30.395
R5413 EAOUT.n419 EAOUT.n418 8.1765
R5414 EAOUT.n418 EAOUT.t106 30.395
R5415 EAOUT.n418 EAOUT.n404 6.1325
R5416 EAOUT.n404 EAOUT.n417 2.0445
R5417 EAOUT.n417 EAOUT.t105 30.395
R5418 EAOUT.n405 EAOUT.n417 1.6065
R5419 EAOUT.n405 EAOUT.n416 6.5705
R5420 EAOUT.n416 EAOUT.t104 30.395
R5421 EAOUT.n416 EAOUT.n415 8.1765
R5422 EAOUT.n415 EAOUT.t103 30.395
R5423 EAOUT.n415 EAOUT.n406 4.2345
R5424 EAOUT.n406 EAOUT.n414 3.9425
R5425 EAOUT.n414 EAOUT.t102 30.395
R5426 EAOUT.n414 EAOUT.n413 8.1765
R5427 EAOUT.n413 EAOUT.t101 30.395
R5428 EAOUT.n413 EAOUT.n407 6.8625
R5429 EAOUT.n407 EAOUT.n412 1.3145
R5430 EAOUT.n412 EAOUT.t100 30.395
R5431 EAOUT.n412 EAOUT.n408 2.3365
R5432 EAOUT.n408 EAOUT.n411 5.8405
R5433 EAOUT.n411 EAOUT.t99 30.395
R5434 EAOUT.n411 EAOUT.n410 8.1765
R5435 EAOUT.n410 EAOUT.t98 30.395
R5436 EAOUT.n410 EAOUT.n409 4.9645
R5437 EAOUT.n409 EAOUT.t97 33.607
R5438 EAOUT.n265 EAOUT.n322 12.5005
R5439 EAOUT.n266 EAOUT.n323 12.5005
R5440 EAOUT.n267 EAOUT.n324 12.5005
R5441 EAOUT.n268 EAOUT.n321 12.5005
R5442 EAOUT.n269 EAOUT.n320 12.5005
R5443 EAOUT.n270 EAOUT.n326 12.5005
R5444 EAOUT.n271 EAOUT.n327 12.5005
R5445 EAOUT.n272 EAOUT.n319 12.5005
R5446 EAOUT.n273 EAOUT.n328 12.5005
R5447 EAOUT.n274 EAOUT.n329 12.5005
R5448 EAOUT.n275 EAOUT.n318 12.5005
R5449 EAOUT.n276 EAOUT.n317 12.5005
R5450 EAOUT.n277 EAOUT.n331 12.5005
R5451 EAOUT.n278 EAOUT.n332 12.5005
R5452 EAOUT.n279 EAOUT.n316 12.5005
R5453 EAOUT.n280 EAOUT.n315 12.5005
R5454 EAOUT.n281 EAOUT.n334 12.5005
R5455 EAOUT.n282 EAOUT.n314 12.5005
R5456 EAOUT.n283 EAOUT.n313 12.5005
R5457 EAOUT.n284 EAOUT.n336 12.5005
R5458 EAOUT.n285 EAOUT.n337 12.5005
R5459 EAOUT.n286 EAOUT.n312 12.5005
R5460 EAOUT.n287 EAOUT.n311 12.5005
R5461 EAOUT.n288 EAOUT.n339 12.5005
R5462 EAOUT.n289 EAOUT.n310 12.5005
R5463 EAOUT.n290 EAOUT.n309 12.5005
R5464 EAOUT.n291 EAOUT.n341 12.5005
R5465 EAOUT.n292 EAOUT.n342 12.5005
R5466 EAOUT.n293 EAOUT.n308 12.5005
R5467 EAOUT.n294 EAOUT.n307 12.5005
R5468 EAOUT.n295 EAOUT.n344 12.5005
R5469 EAOUT.n296 EAOUT.n345 12.5005
R5470 EAOUT.n297 EAOUT.n306 12.5005
R5471 EAOUT.n298 EAOUT.n346 12.5005
R5472 EAOUT.n299 EAOUT.n347 12.5005
R5473 EAOUT.n300 EAOUT.n305 12.5005
R5474 EAOUT.n301 EAOUT.n304 12.5005
R5475 EAOUT.n302 EAOUT.n349 12.5005
R5476 EAOUT.n303 EAOUT.n350 2.06191
R5477 EAOUT.n302 EAOUT.n303 5.39444
R5478 EAOUT.n301 EAOUT.n302 0.1445
R5479 EAOUT.n300 EAOUT.n301 0.1445
R5480 EAOUT.n299 EAOUT.n300 0.1445
R5481 EAOUT.n298 EAOUT.n299 0.1445
R5482 EAOUT.n297 EAOUT.n298 0.1445
R5483 EAOUT.n296 EAOUT.n297 0.1445
R5484 EAOUT.n295 EAOUT.n296 0.1445
R5485 EAOUT.n294 EAOUT.n295 0.1445
R5486 EAOUT.n293 EAOUT.n294 0.1445
R5487 EAOUT.n292 EAOUT.n293 0.1445
R5488 EAOUT.n291 EAOUT.n292 0.1445
R5489 EAOUT.n290 EAOUT.n291 0.1445
R5490 EAOUT.n289 EAOUT.n290 0.1445
R5491 EAOUT.n288 EAOUT.n289 0.1445
R5492 EAOUT.n287 EAOUT.n288 0.1445
R5493 EAOUT.n286 EAOUT.n287 0.1445
R5494 EAOUT.n285 EAOUT.n286 0.1445
R5495 EAOUT.n284 EAOUT.n285 0.1445
R5496 EAOUT.n283 EAOUT.n284 0.1445
R5497 EAOUT.n282 EAOUT.n283 0.1445
R5498 EAOUT.n281 EAOUT.n282 0.1445
R5499 EAOUT.n280 EAOUT.n281 0.1445
R5500 EAOUT.n279 EAOUT.n280 0.1445
R5501 EAOUT.n278 EAOUT.n279 0.1445
R5502 EAOUT.n277 EAOUT.n278 0.1445
R5503 EAOUT.n276 EAOUT.n277 0.1445
R5504 EAOUT.n275 EAOUT.n276 0.1445
R5505 EAOUT.n274 EAOUT.n275 0.1445
R5506 EAOUT.n273 EAOUT.n274 0.1445
R5507 EAOUT.n272 EAOUT.n273 0.1445
R5508 EAOUT.n271 EAOUT.n272 0.1445
R5509 EAOUT.n270 EAOUT.n271 0.1445
R5510 EAOUT.n269 EAOUT.n270 0.1445
R5511 EAOUT.n268 EAOUT.n269 0.1445
R5512 EAOUT.n267 EAOUT.n268 0.1445
R5513 EAOUT.n266 EAOUT.n267 0.1445
R5514 EAOUT.n265 EAOUT.n266 0.1445
R5515 EAOUT.n351 EAOUT.n265 4.7921
R5516 EAOUT.n303 EAOUT.t156 35.6922
R5517 EAOUT.n350 EAOUT.t155 30.395
R5518 EAOUT.n350 EAOUT.n349 8.1765
R5519 EAOUT.n349 EAOUT.t154 30.395
R5520 EAOUT.n349 EAOUT.n304 5.8405
R5521 EAOUT.n304 EAOUT.n348 2.3365
R5522 EAOUT.n348 EAOUT.t153 30.395
R5523 EAOUT.n305 EAOUT.n348 1.3145
R5524 EAOUT.n305 EAOUT.n347 6.8625
R5525 EAOUT.n347 EAOUT.t152 30.395
R5526 EAOUT.n347 EAOUT.n346 8.1765
R5527 EAOUT.n346 EAOUT.t151 30.395
R5528 EAOUT.n346 EAOUT.n306 3.9425
R5529 EAOUT.n306 EAOUT.n345 4.2345
R5530 EAOUT.n345 EAOUT.t150 30.395
R5531 EAOUT.n345 EAOUT.n344 8.1765
R5532 EAOUT.n344 EAOUT.t149 30.395
R5533 EAOUT.n344 EAOUT.n307 6.5705
R5534 EAOUT.n307 EAOUT.n343 1.6065
R5535 EAOUT.n343 EAOUT.t148 30.395
R5536 EAOUT.n343 EAOUT.n308 2.0445
R5537 EAOUT.n308 EAOUT.n342 6.1325
R5538 EAOUT.n342 EAOUT.t147 30.395
R5539 EAOUT.n342 EAOUT.n341 8.1765
R5540 EAOUT.n341 EAOUT.t146 30.395
R5541 EAOUT.n341 EAOUT.n309 4.6725
R5542 EAOUT.n309 EAOUT.n340 3.5045
R5543 EAOUT.n340 EAOUT.t145 30.395
R5544 EAOUT.n310 EAOUT.n340 0.1465
R5545 EAOUT.n310 EAOUT.n339 8.0305
R5546 EAOUT.n339 EAOUT.t144 30.395
R5547 EAOUT.n339 EAOUT.n311 7.3005
R5548 EAOUT.n311 EAOUT.n338 0.8765
R5549 EAOUT.n338 EAOUT.t143 30.395
R5550 EAOUT.n338 EAOUT.n312 2.7745
R5551 EAOUT.n312 EAOUT.n337 5.4025
R5552 EAOUT.n337 EAOUT.t142 30.395
R5553 EAOUT.n337 EAOUT.n336 8.1765
R5554 EAOUT.n336 EAOUT.t141 30.395
R5555 EAOUT.n336 EAOUT.n313 5.4025
R5556 EAOUT.n313 EAOUT.n335 2.7745
R5557 EAOUT.n335 EAOUT.t140 30.395
R5558 EAOUT.n314 EAOUT.n335 0.8765
R5559 EAOUT.n314 EAOUT.n334 7.3005
R5560 EAOUT.n334 EAOUT.t139 30.395
R5561 EAOUT.n334 EAOUT.n315 8.0305
R5562 EAOUT.n315 EAOUT.n333 0.1465
R5563 EAOUT.n333 EAOUT.t138 30.395
R5564 EAOUT.n333 EAOUT.n316 3.5045
R5565 EAOUT.n316 EAOUT.n332 4.6725
R5566 EAOUT.n332 EAOUT.t137 30.395
R5567 EAOUT.n332 EAOUT.n331 8.1765
R5568 EAOUT.n331 EAOUT.t136 30.395
R5569 EAOUT.n331 EAOUT.n317 6.1325
R5570 EAOUT.n317 EAOUT.n330 2.0445
R5571 EAOUT.n330 EAOUT.t135 30.395
R5572 EAOUT.n318 EAOUT.n330 1.6065
R5573 EAOUT.n318 EAOUT.n329 6.5705
R5574 EAOUT.n329 EAOUT.t134 30.395
R5575 EAOUT.n329 EAOUT.n328 8.1765
R5576 EAOUT.n328 EAOUT.t133 30.395
R5577 EAOUT.n328 EAOUT.n319 4.2345
R5578 EAOUT.n319 EAOUT.n327 3.9425
R5579 EAOUT.n327 EAOUT.t132 30.395
R5580 EAOUT.n327 EAOUT.n326 8.1765
R5581 EAOUT.n326 EAOUT.t131 30.395
R5582 EAOUT.n326 EAOUT.n320 6.8625
R5583 EAOUT.n320 EAOUT.n325 1.3145
R5584 EAOUT.n325 EAOUT.t130 30.395
R5585 EAOUT.n325 EAOUT.n321 2.3365
R5586 EAOUT.n321 EAOUT.n324 5.8405
R5587 EAOUT.n324 EAOUT.t129 30.395
R5588 EAOUT.n324 EAOUT.n323 8.1765
R5589 EAOUT.n323 EAOUT.t128 30.395
R5590 EAOUT.n323 EAOUT.n322 4.9645
R5591 EAOUT.n322 EAOUT.t127 33.607
R5592 EAOUT.n178 EAOUT.n235 12.5005
R5593 EAOUT.n179 EAOUT.n236 12.5005
R5594 EAOUT.n180 EAOUT.n237 12.5005
R5595 EAOUT.n181 EAOUT.n234 12.5005
R5596 EAOUT.n182 EAOUT.n233 12.5005
R5597 EAOUT.n183 EAOUT.n239 12.5005
R5598 EAOUT.n184 EAOUT.n240 12.5005
R5599 EAOUT.n185 EAOUT.n232 12.5005
R5600 EAOUT.n186 EAOUT.n241 12.5005
R5601 EAOUT.n187 EAOUT.n242 12.5005
R5602 EAOUT.n188 EAOUT.n231 12.5005
R5603 EAOUT.n189 EAOUT.n230 12.5005
R5604 EAOUT.n190 EAOUT.n244 12.5005
R5605 EAOUT.n191 EAOUT.n245 12.5005
R5606 EAOUT.n192 EAOUT.n229 12.5005
R5607 EAOUT.n193 EAOUT.n228 12.5005
R5608 EAOUT.n194 EAOUT.n247 12.5005
R5609 EAOUT.n195 EAOUT.n227 12.5005
R5610 EAOUT.n196 EAOUT.n226 12.5005
R5611 EAOUT.n197 EAOUT.n249 12.5005
R5612 EAOUT.n198 EAOUT.n250 12.5005
R5613 EAOUT.n199 EAOUT.n225 12.5005
R5614 EAOUT.n200 EAOUT.n224 12.5005
R5615 EAOUT.n201 EAOUT.n252 12.5005
R5616 EAOUT.n202 EAOUT.n223 12.5005
R5617 EAOUT.n203 EAOUT.n222 12.5005
R5618 EAOUT.n204 EAOUT.n254 12.5005
R5619 EAOUT.n205 EAOUT.n255 12.5005
R5620 EAOUT.n206 EAOUT.n221 12.5005
R5621 EAOUT.n207 EAOUT.n220 12.5005
R5622 EAOUT.n208 EAOUT.n257 12.5005
R5623 EAOUT.n209 EAOUT.n258 12.5005
R5624 EAOUT.n210 EAOUT.n219 12.5005
R5625 EAOUT.n211 EAOUT.n259 12.5005
R5626 EAOUT.n212 EAOUT.n260 12.5005
R5627 EAOUT.n213 EAOUT.n218 12.5005
R5628 EAOUT.n214 EAOUT.n217 12.5005
R5629 EAOUT.n215 EAOUT.n262 12.5005
R5630 EAOUT.n216 EAOUT.n263 2.06191
R5631 EAOUT.n215 EAOUT.n216 5.39444
R5632 EAOUT.n214 EAOUT.n215 0.1445
R5633 EAOUT.n213 EAOUT.n214 0.1445
R5634 EAOUT.n212 EAOUT.n213 0.1445
R5635 EAOUT.n211 EAOUT.n212 0.1445
R5636 EAOUT.n210 EAOUT.n211 0.1445
R5637 EAOUT.n209 EAOUT.n210 0.1445
R5638 EAOUT.n208 EAOUT.n209 0.1445
R5639 EAOUT.n207 EAOUT.n208 0.1445
R5640 EAOUT.n206 EAOUT.n207 0.1445
R5641 EAOUT.n205 EAOUT.n206 0.1445
R5642 EAOUT.n204 EAOUT.n205 0.1445
R5643 EAOUT.n203 EAOUT.n204 0.1445
R5644 EAOUT.n202 EAOUT.n203 0.1445
R5645 EAOUT.n201 EAOUT.n202 0.1445
R5646 EAOUT.n200 EAOUT.n201 0.1445
R5647 EAOUT.n199 EAOUT.n200 0.1445
R5648 EAOUT.n198 EAOUT.n199 0.1445
R5649 EAOUT.n197 EAOUT.n198 0.1445
R5650 EAOUT.n196 EAOUT.n197 0.1445
R5651 EAOUT.n195 EAOUT.n196 0.1445
R5652 EAOUT.n194 EAOUT.n195 0.1445
R5653 EAOUT.n193 EAOUT.n194 0.1445
R5654 EAOUT.n192 EAOUT.n193 0.1445
R5655 EAOUT.n191 EAOUT.n192 0.1445
R5656 EAOUT.n190 EAOUT.n191 0.1445
R5657 EAOUT.n189 EAOUT.n190 0.1445
R5658 EAOUT.n188 EAOUT.n189 0.1445
R5659 EAOUT.n187 EAOUT.n188 0.1445
R5660 EAOUT.n186 EAOUT.n187 0.1445
R5661 EAOUT.n185 EAOUT.n186 0.1445
R5662 EAOUT.n184 EAOUT.n185 0.1445
R5663 EAOUT.n183 EAOUT.n184 0.1445
R5664 EAOUT.n182 EAOUT.n183 0.1445
R5665 EAOUT.n181 EAOUT.n182 0.1445
R5666 EAOUT.n180 EAOUT.n181 0.1445
R5667 EAOUT.n179 EAOUT.n180 0.1445
R5668 EAOUT.n178 EAOUT.n179 0.1445
R5669 EAOUT.n264 EAOUT.n178 4.7921
R5670 EAOUT.n216 EAOUT.t186 35.6922
R5671 EAOUT.n263 EAOUT.t185 30.395
R5672 EAOUT.n263 EAOUT.n262 8.1765
R5673 EAOUT.n262 EAOUT.t184 30.395
R5674 EAOUT.n262 EAOUT.n217 5.8405
R5675 EAOUT.n217 EAOUT.n261 2.3365
R5676 EAOUT.n261 EAOUT.t183 30.395
R5677 EAOUT.n218 EAOUT.n261 1.3145
R5678 EAOUT.n218 EAOUT.n260 6.8625
R5679 EAOUT.n260 EAOUT.t182 30.395
R5680 EAOUT.n260 EAOUT.n259 8.1765
R5681 EAOUT.n259 EAOUT.t181 30.395
R5682 EAOUT.n259 EAOUT.n219 3.9425
R5683 EAOUT.n219 EAOUT.n258 4.2345
R5684 EAOUT.n258 EAOUT.t180 30.395
R5685 EAOUT.n258 EAOUT.n257 8.1765
R5686 EAOUT.n257 EAOUT.t179 30.395
R5687 EAOUT.n257 EAOUT.n220 6.5705
R5688 EAOUT.n220 EAOUT.n256 1.6065
R5689 EAOUT.n256 EAOUT.t178 30.395
R5690 EAOUT.n256 EAOUT.n221 2.0445
R5691 EAOUT.n221 EAOUT.n255 6.1325
R5692 EAOUT.n255 EAOUT.t177 30.395
R5693 EAOUT.n255 EAOUT.n254 8.1765
R5694 EAOUT.n254 EAOUT.t176 30.395
R5695 EAOUT.n254 EAOUT.n222 4.6725
R5696 EAOUT.n222 EAOUT.n253 3.5045
R5697 EAOUT.n253 EAOUT.t175 30.395
R5698 EAOUT.n223 EAOUT.n253 0.1465
R5699 EAOUT.n223 EAOUT.n252 8.0305
R5700 EAOUT.n252 EAOUT.t174 30.395
R5701 EAOUT.n252 EAOUT.n224 7.3005
R5702 EAOUT.n224 EAOUT.n251 0.8765
R5703 EAOUT.n251 EAOUT.t173 30.395
R5704 EAOUT.n251 EAOUT.n225 2.7745
R5705 EAOUT.n225 EAOUT.n250 5.4025
R5706 EAOUT.n250 EAOUT.t172 30.395
R5707 EAOUT.n250 EAOUT.n249 8.1765
R5708 EAOUT.n249 EAOUT.t171 30.395
R5709 EAOUT.n249 EAOUT.n226 5.4025
R5710 EAOUT.n226 EAOUT.n248 2.7745
R5711 EAOUT.n248 EAOUT.t170 30.395
R5712 EAOUT.n227 EAOUT.n248 0.8765
R5713 EAOUT.n227 EAOUT.n247 7.3005
R5714 EAOUT.n247 EAOUT.t169 30.395
R5715 EAOUT.n247 EAOUT.n228 8.0305
R5716 EAOUT.n228 EAOUT.n246 0.1465
R5717 EAOUT.n246 EAOUT.t168 30.395
R5718 EAOUT.n246 EAOUT.n229 3.5045
R5719 EAOUT.n229 EAOUT.n245 4.6725
R5720 EAOUT.n245 EAOUT.t167 30.395
R5721 EAOUT.n245 EAOUT.n244 8.1765
R5722 EAOUT.n244 EAOUT.t166 30.395
R5723 EAOUT.n244 EAOUT.n230 6.1325
R5724 EAOUT.n230 EAOUT.n243 2.0445
R5725 EAOUT.n243 EAOUT.t165 30.395
R5726 EAOUT.n231 EAOUT.n243 1.6065
R5727 EAOUT.n231 EAOUT.n242 6.5705
R5728 EAOUT.n242 EAOUT.t164 30.395
R5729 EAOUT.n242 EAOUT.n241 8.1765
R5730 EAOUT.n241 EAOUT.t163 30.395
R5731 EAOUT.n241 EAOUT.n232 4.2345
R5732 EAOUT.n232 EAOUT.n240 3.9425
R5733 EAOUT.n240 EAOUT.t162 30.395
R5734 EAOUT.n240 EAOUT.n239 8.1765
R5735 EAOUT.n239 EAOUT.t161 30.395
R5736 EAOUT.n239 EAOUT.n233 6.8625
R5737 EAOUT.n233 EAOUT.n238 1.3145
R5738 EAOUT.n238 EAOUT.t160 30.395
R5739 EAOUT.n238 EAOUT.n234 2.3365
R5740 EAOUT.n234 EAOUT.n237 5.8405
R5741 EAOUT.n237 EAOUT.t159 30.395
R5742 EAOUT.n237 EAOUT.n236 8.1765
R5743 EAOUT.n236 EAOUT.t158 30.395
R5744 EAOUT.n236 EAOUT.n235 4.9645
R5745 EAOUT.n235 EAOUT.t157 33.607
R5746 EAOUT.n92 EAOUT.n148 2.06191
R5747 EAOUT.n93 EAOUT.n149 12.5005
R5748 EAOUT.n94 EAOUT.n147 12.5005
R5749 EAOUT.n95 EAOUT.n146 12.5005
R5750 EAOUT.n96 EAOUT.n151 12.5005
R5751 EAOUT.n97 EAOUT.n152 12.5005
R5752 EAOUT.n98 EAOUT.n145 12.5005
R5753 EAOUT.n99 EAOUT.n153 12.5005
R5754 EAOUT.n100 EAOUT.n154 12.5005
R5755 EAOUT.n101 EAOUT.n144 12.5005
R5756 EAOUT.n102 EAOUT.n143 12.5005
R5757 EAOUT.n103 EAOUT.n156 12.5005
R5758 EAOUT.n104 EAOUT.n157 12.5005
R5759 EAOUT.n105 EAOUT.n142 12.5005
R5760 EAOUT.n106 EAOUT.n141 12.5005
R5761 EAOUT.n107 EAOUT.n159 12.5005
R5762 EAOUT.n108 EAOUT.n140 12.5005
R5763 EAOUT.n109 EAOUT.n139 12.5005
R5764 EAOUT.n110 EAOUT.n161 12.5005
R5765 EAOUT.n111 EAOUT.n162 12.5005
R5766 EAOUT.n112 EAOUT.n138 12.5005
R5767 EAOUT.n113 EAOUT.n137 12.5005
R5768 EAOUT.n114 EAOUT.n164 12.5005
R5769 EAOUT.n115 EAOUT.n136 12.5005
R5770 EAOUT.n116 EAOUT.n135 12.5005
R5771 EAOUT.n117 EAOUT.n166 12.5005
R5772 EAOUT.n118 EAOUT.n167 12.5005
R5773 EAOUT.n119 EAOUT.n134 12.5005
R5774 EAOUT.n120 EAOUT.n133 12.5005
R5775 EAOUT.n121 EAOUT.n169 12.5005
R5776 EAOUT.n122 EAOUT.n170 12.5005
R5777 EAOUT.n123 EAOUT.n132 12.5005
R5778 EAOUT.n124 EAOUT.n171 12.5005
R5779 EAOUT.n125 EAOUT.n172 12.5005
R5780 EAOUT.n126 EAOUT.n131 12.5005
R5781 EAOUT.n127 EAOUT.n130 12.5005
R5782 EAOUT.n128 EAOUT.n174 12.5005
R5783 EAOUT.n129 EAOUT.n175 12.5005
R5784 EAOUT.n93 EAOUT.n92 5.39444
R5785 EAOUT.n94 EAOUT.n93 0.1445
R5786 EAOUT.n95 EAOUT.n94 0.1445
R5787 EAOUT.n96 EAOUT.n95 0.1445
R5788 EAOUT.n97 EAOUT.n96 0.1445
R5789 EAOUT.n98 EAOUT.n97 0.1445
R5790 EAOUT.n99 EAOUT.n98 0.1445
R5791 EAOUT.n100 EAOUT.n99 0.1445
R5792 EAOUT.n101 EAOUT.n100 0.1445
R5793 EAOUT.n102 EAOUT.n101 0.1445
R5794 EAOUT.n103 EAOUT.n102 0.1445
R5795 EAOUT.n104 EAOUT.n103 0.1445
R5796 EAOUT.n105 EAOUT.n104 0.1445
R5797 EAOUT.n106 EAOUT.n105 0.1445
R5798 EAOUT.n107 EAOUT.n106 0.1445
R5799 EAOUT.n108 EAOUT.n107 0.1445
R5800 EAOUT.n109 EAOUT.n108 0.1445
R5801 EAOUT.n110 EAOUT.n109 0.1445
R5802 EAOUT.n111 EAOUT.n110 0.1445
R5803 EAOUT.n112 EAOUT.n111 0.1445
R5804 EAOUT.n113 EAOUT.n112 0.1445
R5805 EAOUT.n114 EAOUT.n113 0.1445
R5806 EAOUT.n115 EAOUT.n114 0.1445
R5807 EAOUT.n116 EAOUT.n115 0.1445
R5808 EAOUT.n117 EAOUT.n116 0.1445
R5809 EAOUT.n118 EAOUT.n117 0.1445
R5810 EAOUT.n119 EAOUT.n118 0.1445
R5811 EAOUT.n120 EAOUT.n119 0.1445
R5812 EAOUT.n121 EAOUT.n120 0.1445
R5813 EAOUT.n122 EAOUT.n121 0.1445
R5814 EAOUT.n123 EAOUT.n122 0.1445
R5815 EAOUT.n124 EAOUT.n123 0.1445
R5816 EAOUT.n125 EAOUT.n124 0.1445
R5817 EAOUT.n126 EAOUT.n125 0.1445
R5818 EAOUT.n127 EAOUT.n126 0.1445
R5819 EAOUT.n128 EAOUT.n127 0.1445
R5820 EAOUT.n129 EAOUT.n128 0.1445
R5821 EAOUT.n177 EAOUT.n129 0.1445
R5822 EAOUT.n264 EAOUT.n177 5.9063
R5823 EAOUT.n177 EAOUT.n176 12.5005
R5824 EAOUT.n175 EAOUT.n176 4.9645
R5825 EAOUT.n176 EAOUT.t187 33.607
R5826 EAOUT.n175 EAOUT.t188 30.395
R5827 EAOUT.n174 EAOUT.n175 8.1765
R5828 EAOUT.n174 EAOUT.t189 30.395
R5829 EAOUT.n173 EAOUT.n130 2.3365
R5830 EAOUT.n130 EAOUT.n174 5.8405
R5831 EAOUT.n173 EAOUT.t190 30.395
R5832 EAOUT.n172 EAOUT.n131 6.8625
R5833 EAOUT.n131 EAOUT.n173 1.3145
R5834 EAOUT.n172 EAOUT.t191 30.395
R5835 EAOUT.n171 EAOUT.n172 8.1765
R5836 EAOUT.n171 EAOUT.t192 30.395
R5837 EAOUT.n170 EAOUT.n132 4.2345
R5838 EAOUT.n132 EAOUT.n171 3.9425
R5839 EAOUT.n170 EAOUT.t193 30.395
R5840 EAOUT.n169 EAOUT.n170 8.1765
R5841 EAOUT.n169 EAOUT.t194 30.395
R5842 EAOUT.n133 EAOUT.n168 1.6065
R5843 EAOUT.n133 EAOUT.n169 6.5705
R5844 EAOUT.n168 EAOUT.t195 30.395
R5845 EAOUT.n167 EAOUT.n134 6.1325
R5846 EAOUT.n134 EAOUT.n168 2.0445
R5847 EAOUT.n167 EAOUT.t196 30.395
R5848 EAOUT.n166 EAOUT.n167 8.1765
R5849 EAOUT.n166 EAOUT.t197 30.395
R5850 EAOUT.n165 EAOUT.n135 3.5045
R5851 EAOUT.n135 EAOUT.n166 4.6725
R5852 EAOUT.n165 EAOUT.t198 30.395
R5853 EAOUT.n164 EAOUT.n136 8.0305
R5854 EAOUT.n136 EAOUT.n165 0.1465
R5855 EAOUT.n164 EAOUT.t199 30.395
R5856 EAOUT.n137 EAOUT.n163 0.8765
R5857 EAOUT.n137 EAOUT.n164 7.3005
R5858 EAOUT.n163 EAOUT.t200 30.395
R5859 EAOUT.n162 EAOUT.n138 5.4025
R5860 EAOUT.n138 EAOUT.n163 2.7745
R5861 EAOUT.n162 EAOUT.t201 30.395
R5862 EAOUT.n161 EAOUT.n162 8.1765
R5863 EAOUT.n161 EAOUT.t202 30.395
R5864 EAOUT.n160 EAOUT.n139 2.7745
R5865 EAOUT.n139 EAOUT.n161 5.4025
R5866 EAOUT.n160 EAOUT.t203 30.395
R5867 EAOUT.n159 EAOUT.n140 7.3005
R5868 EAOUT.n140 EAOUT.n160 0.8765
R5869 EAOUT.n159 EAOUT.t204 30.395
R5870 EAOUT.n141 EAOUT.n158 0.1465
R5871 EAOUT.n141 EAOUT.n159 8.0305
R5872 EAOUT.n158 EAOUT.t205 30.395
R5873 EAOUT.n157 EAOUT.n142 4.6725
R5874 EAOUT.n142 EAOUT.n158 3.5045
R5875 EAOUT.n157 EAOUT.t206 30.395
R5876 EAOUT.n156 EAOUT.n157 8.1765
R5877 EAOUT.n156 EAOUT.t207 30.395
R5878 EAOUT.n155 EAOUT.n143 2.0445
R5879 EAOUT.n143 EAOUT.n156 6.1325
R5880 EAOUT.n155 EAOUT.t208 30.395
R5881 EAOUT.n154 EAOUT.n144 6.5705
R5882 EAOUT.n144 EAOUT.n155 1.6065
R5883 EAOUT.n154 EAOUT.t209 30.395
R5884 EAOUT.n153 EAOUT.n154 8.1765
R5885 EAOUT.n153 EAOUT.t210 30.395
R5886 EAOUT.n152 EAOUT.n145 3.9425
R5887 EAOUT.n145 EAOUT.n153 4.2345
R5888 EAOUT.n152 EAOUT.t211 30.395
R5889 EAOUT.n151 EAOUT.n152 8.1765
R5890 EAOUT.n151 EAOUT.t212 30.395
R5891 EAOUT.n146 EAOUT.n150 1.3145
R5892 EAOUT.n146 EAOUT.n151 6.8625
R5893 EAOUT.n150 EAOUT.t213 30.395
R5894 EAOUT.n149 EAOUT.n147 5.8405
R5895 EAOUT.n147 EAOUT.n150 2.3365
R5896 EAOUT.n149 EAOUT.t214 30.395
R5897 EAOUT.n148 EAOUT.n149 8.1765
R5898 EAOUT.n148 EAOUT.t215 30.395
R5899 EAOUT.n92 EAOUT.t216 35.6922
R5900 EAOUT.n91 EAOUT.n90 12.5005
R5901 EAOUT.n90 EAOUT.n89 4.9645
R5902 EAOUT.n89 EAOUT.t35 30.395
R5903 EAOUT.n89 EAOUT.n88 8.1765
R5904 EAOUT.n88 EAOUT.t34 30.395
R5905 EAOUT.n88 EAOUT.n43 5.8405
R5906 EAOUT.n43 EAOUT.n87 2.3365
R5907 EAOUT.n87 EAOUT.t33 30.395
R5908 EAOUT.n44 EAOUT.n87 1.3145
R5909 EAOUT.n44 EAOUT.n86 6.8625
R5910 EAOUT.n86 EAOUT.t32 30.395
R5911 EAOUT.n86 EAOUT.n85 8.1765
R5912 EAOUT.n85 EAOUT.t31 30.395
R5913 EAOUT.n85 EAOUT.n45 3.9425
R5914 EAOUT.n45 EAOUT.n84 4.2345
R5915 EAOUT.n84 EAOUT.t30 30.395
R5916 EAOUT.n84 EAOUT.n83 8.1765
R5917 EAOUT.n83 EAOUT.t29 30.395
R5918 EAOUT.n83 EAOUT.n46 6.5705
R5919 EAOUT.n46 EAOUT.n82 1.6065
R5920 EAOUT.n82 EAOUT.t28 30.395
R5921 EAOUT.n82 EAOUT.n47 2.0445
R5922 EAOUT.n47 EAOUT.n81 6.1325
R5923 EAOUT.n81 EAOUT.t27 30.395
R5924 EAOUT.n81 EAOUT.n80 8.1765
R5925 EAOUT.n80 EAOUT.t26 30.395
R5926 EAOUT.n80 EAOUT.n48 4.6725
R5927 EAOUT.n48 EAOUT.n79 3.5045
R5928 EAOUT.n79 EAOUT.t25 30.395
R5929 EAOUT.n49 EAOUT.n79 0.1465
R5930 EAOUT.n49 EAOUT.n78 8.0305
R5931 EAOUT.n78 EAOUT.t24 30.395
R5932 EAOUT.n78 EAOUT.n50 7.3005
R5933 EAOUT.n50 EAOUT.n77 0.8765
R5934 EAOUT.n77 EAOUT.t23 30.395
R5935 EAOUT.n77 EAOUT.n51 2.7745
R5936 EAOUT.n51 EAOUT.n76 5.4025
R5937 EAOUT.n76 EAOUT.t22 30.395
R5938 EAOUT.n76 EAOUT.n75 8.1765
R5939 EAOUT.n75 EAOUT.t21 30.395
R5940 EAOUT.n75 EAOUT.n52 5.4025
R5941 EAOUT.n52 EAOUT.n74 2.7745
R5942 EAOUT.n74 EAOUT.t20 30.395
R5943 EAOUT.n53 EAOUT.n74 0.8765
R5944 EAOUT.n53 EAOUT.n73 7.3005
R5945 EAOUT.n73 EAOUT.t19 30.395
R5946 EAOUT.n73 EAOUT.n54 8.0305
R5947 EAOUT.n54 EAOUT.n72 0.1465
R5948 EAOUT.n72 EAOUT.t18 30.395
R5949 EAOUT.n72 EAOUT.n55 3.5045
R5950 EAOUT.n55 EAOUT.n71 4.6725
R5951 EAOUT.n71 EAOUT.t17 30.395
R5952 EAOUT.n71 EAOUT.n70 8.1765
R5953 EAOUT.n70 EAOUT.t16 30.395
R5954 EAOUT.n70 EAOUT.n56 6.1325
R5955 EAOUT.n56 EAOUT.n69 2.0445
R5956 EAOUT.n69 EAOUT.t15 30.395
R5957 EAOUT.n57 EAOUT.n69 1.6065
R5958 EAOUT.n57 EAOUT.n68 6.5705
R5959 EAOUT.n68 EAOUT.t14 30.395
R5960 EAOUT.n68 EAOUT.n67 8.1765
R5961 EAOUT.n67 EAOUT.t13 30.395
R5962 EAOUT.n67 EAOUT.n58 4.2345
R5963 EAOUT.n58 EAOUT.n66 3.9425
R5964 EAOUT.n66 EAOUT.t12 30.395
R5965 EAOUT.n66 EAOUT.n65 8.1765
R5966 EAOUT.n65 EAOUT.t11 30.395
R5967 EAOUT.n65 EAOUT.n59 6.8625
R5968 EAOUT.n59 EAOUT.n64 1.3145
R5969 EAOUT.n64 EAOUT.t10 30.395
R5970 EAOUT.n64 EAOUT.n60 2.3365
R5971 EAOUT.n60 EAOUT.n63 5.8405
R5972 EAOUT.n63 EAOUT.t9 30.395
R5973 EAOUT.n63 EAOUT.n62 8.1765
R5974 EAOUT.n62 EAOUT.t8 30.395
R5975 EAOUT.n62 EAOUT.n61 4.9645
R5976 EAOUT.n61 EAOUT.t7 33.607
R5977 EAOUT.n90 EAOUT.t36 33.607
R5978 EAOUT.n3 EAOUT.t5 10.5471
R5979 EAOUT.n0 EAOUT.t2 7.99732
R5980 a_11564_14636.n0 a_11564_14636.t1 0.3925
R5981 a_11564_14636.t2 a_11564_14636.n0 0.3925
R5982 a_11564_14636.n0 a_11564_14636.n1 16.3708
R5983 a_11564_14636.n1 a_11564_14636.t3 30.2707
R5984 a_11564_14636.n1 a_11564_14636.t0 59.5519
R5985 a_644_14636.t3 a_644_14636.n0 8.49776
R5986 a_644_14636.n1 a_644_14636.t4 30.8867
R5987 a_644_14636.n0 a_644_14636.n1 14.4514
R5988 a_644_14636.n1 a_644_14636.n7 9.0005
R5989 a_644_14636.n7 a_644_14636.n5 15.9773
R5990 a_644_14636.n5 a_644_14636.n3 0.411421
R5991 a_644_14636.n3 a_644_14636.n2 12.6083
R5992 a_644_14636.n5 a_644_14636.n6 11.2708
R5993 a_644_14636.n6 a_644_14636.t2 38.6921
R5994 a_644_14636.n6 a_644_14636.t0 37.3205
R5995 a_644_14636.n3 a_644_14636.n4 10.9994
R5996 a_644_14636.n4 a_644_14636.t6 52.2311
R5997 a_644_14636.n4 a_644_14636.t9 51.4625
R5998 a_644_14636.n2 a_644_14636.t7 64.0872
R5999 a_644_14636.n2 a_644_14636.t8 64.5444
R6000 a_644_14636.n7 a_644_14636.t5 50.4229
R6001 a_644_14636.n0 a_644_14636.t1 7.52396
C42 VREF VSS 6.14054f
C43 EAOUT_BUF VSS 12.51044f
C44 FB_BUF VSS 11.56811f
C45 EN VSS 4.14904f
C46 VOUT VSS 41.58813f
C47 VIN VSS 0.38874p
C48 a_1786_3337# VSS 18.6782f ; **FLOATING
C49 EAOUT VSS 36.65277f ; **FLOATING
C50 a_17452_15075# VSS 1.4069f ; **FLOATING
C51 a_16492_25063# VSS 1.45777f ; **FLOATING
C52 a_16012_25063# VSS 1.38361f ; **FLOATING
C53 a_15532_15075# VSS 1.47046f ; **FLOATING
C54 a_15052_15075# VSS 1.37773f ; **FLOATING
C55 a_14572_25063# VSS 1.47358f ; **FLOATING
C56 a_14092_25063# VSS 1.37661f ; **FLOATING
C57 a_13612_15075# VSS 1.70785f ; **FLOATING
C58 FB VSS 14.2453f ; **FLOATING
C59 a_13132_25063# VSS 1.40397f ; **FLOATING
C60 a_644_14636.t3 VSS 0.3115f ; **FLOATING
C61 a_644_14636.t1 VSS 0.27677f ; **FLOATING
C62 a_644_14636.n0 VSS 0.69373f ; **FLOATING
C63 a_644_14636.n1 VSS 1.05007f ; **FLOATING
C64 a_644_14636.t5 VSS 0.76041f ; **FLOATING
C65 a_644_14636.t8 VSS 0.14177f ; **FLOATING
C66 a_644_14636.t7 VSS 0.14089f ; **FLOATING
C67 a_644_14636.n2 VSS 0.48539f ; **FLOATING
C68 a_644_14636.n3 VSS 0.32188f ; **FLOATING
C69 a_644_14636.t9 VSS 0.13123f ; **FLOATING
C70 a_644_14636.t6 VSS 0.1352f ; **FLOATING
C71 a_644_14636.n4 VSS 0.63211f ; **FLOATING
C72 a_644_14636.n5 VSS 0.44406f ; **FLOATING
C73 a_644_14636.t0 VSS 0.125f ; **FLOATING
C74 a_644_14636.n6 VSS 0.57788f ; **FLOATING
C75 a_644_14636.t2 VSS 0.1348f ; **FLOATING
C76 a_644_14636.n7 VSS 2.2365f ; **FLOATING
C77 a_644_14636.t4 VSS 0.30844f ; **FLOATING
C78 a_11564_14636.t2 VSS 0.08173f ; **FLOATING
C79 a_11564_14636.n0 VSS 1.00004f ; **FLOATING
C80 a_11564_14636.t0 VSS 2.01051f ; **FLOATING
C81 a_11564_14636.t3 VSS 0.49158f ; **FLOATING
C82 a_11564_14636.n1 VSS 5.15688f ; **FLOATING
C83 a_11564_14636.t1 VSS 0.08173f ; **FLOATING
C84 EAOUT.t3 VSS 0.19851f ; **FLOATING
C85 EAOUT.n0 VSS 0.30743f ; **FLOATING
C86 EAOUT.t2 VSS 0.20885f ; **FLOATING
C87 EAOUT.n1 VSS 0.15518f ; **FLOATING
C88 EAOUT.n2 VSS 0.16006f ; **FLOATING
C89 EAOUT.n3 VSS 0.10448f ; **FLOATING
C90 EAOUT.t5 VSS 0.13381p ; **FLOATING
C91 EAOUT.t4 VSS 0.5807f ; **FLOATING
C92 EAOUT.n4 VSS 0.0726f ; **FLOATING
C93 EAOUT.n5 VSS 0.02566f ; **FLOATING
C94 EAOUT.n6 VSS 0.02566f ; **FLOATING
C95 EAOUT.n7 VSS 0.02566f ; **FLOATING
C96 EAOUT.n8 VSS 0.02566f ; **FLOATING
C97 EAOUT.n9 VSS 0.02566f ; **FLOATING
C98 EAOUT.n10 VSS 0.02566f ; **FLOATING
C99 EAOUT.n11 VSS 0.02566f ; **FLOATING
C100 EAOUT.n12 VSS 0.02566f ; **FLOATING
C101 EAOUT.n13 VSS 0.02566f ; **FLOATING
C102 EAOUT.n14 VSS 0.02566f ; **FLOATING
C103 EAOUT.n15 VSS 0.02566f ; **FLOATING
C104 EAOUT.n16 VSS 0.02566f ; **FLOATING
C105 EAOUT.n17 VSS 0.02566f ; **FLOATING
C106 EAOUT.n18 VSS 0.02566f ; **FLOATING
C107 EAOUT.n19 VSS 0.02566f ; **FLOATING
C108 EAOUT.n20 VSS 0.02566f ; **FLOATING
C109 EAOUT.n21 VSS 0.02566f ; **FLOATING
C110 EAOUT.n22 VSS 0.02566f ; **FLOATING
C111 EAOUT.n23 VSS 0.02566f ; **FLOATING
C112 EAOUT.n24 VSS 0.02566f ; **FLOATING
C113 EAOUT.n25 VSS 0.02566f ; **FLOATING
C114 EAOUT.n26 VSS 0.02566f ; **FLOATING
C115 EAOUT.n27 VSS 0.02566f ; **FLOATING
C116 EAOUT.n28 VSS 0.02566f ; **FLOATING
C117 EAOUT.n29 VSS 0.02566f ; **FLOATING
C118 EAOUT.n30 VSS 0.02566f ; **FLOATING
C119 EAOUT.n31 VSS 0.02566f ; **FLOATING
C120 EAOUT.n32 VSS 0.02566f ; **FLOATING
C121 EAOUT.n33 VSS 0.02566f ; **FLOATING
C122 EAOUT.n34 VSS 0.02566f ; **FLOATING
C123 EAOUT.n35 VSS 0.02566f ; **FLOATING
C124 EAOUT.n36 VSS 0.02566f ; **FLOATING
C125 EAOUT.n37 VSS 0.02566f ; **FLOATING
C126 EAOUT.n38 VSS 0.02566f ; **FLOATING
C127 EAOUT.n39 VSS 0.02566f ; **FLOATING
C128 EAOUT.n40 VSS 0.02566f ; **FLOATING
C129 EAOUT.n41 VSS 0.02566f ; **FLOATING
C130 EAOUT.n42 VSS 0.02566f ; **FLOATING
C131 EAOUT.t36 VSS 0.07631f ; **FLOATING
C132 EAOUT.n43 VSS 0.01054f ; **FLOATING
C133 EAOUT.n44 VSS 0.01054f ; **FLOATING
C134 EAOUT.n45 VSS 0.01054f ; **FLOATING
C135 EAOUT.n46 VSS 0.01054f ; **FLOATING
C136 EAOUT.n47 VSS 0.01054f ; **FLOATING
C137 EAOUT.n48 VSS 0.01054f ; **FLOATING
C138 EAOUT.n49 VSS 0.01054f ; **FLOATING
C139 EAOUT.n50 VSS 0.01054f ; **FLOATING
C140 EAOUT.n51 VSS 0.01054f ; **FLOATING
C141 EAOUT.n52 VSS 0.01054f ; **FLOATING
C142 EAOUT.n53 VSS 0.01054f ; **FLOATING
C143 EAOUT.n54 VSS 0.01054f ; **FLOATING
C144 EAOUT.n55 VSS 0.01054f ; **FLOATING
C145 EAOUT.n56 VSS 0.01054f ; **FLOATING
C146 EAOUT.n57 VSS 0.01054f ; **FLOATING
C147 EAOUT.n58 VSS 0.01054f ; **FLOATING
C148 EAOUT.n59 VSS 0.01054f ; **FLOATING
C149 EAOUT.n60 VSS 0.01054f ; **FLOATING
C150 EAOUT.n61 VSS 0.04461f ; **FLOATING
C151 EAOUT.t7 VSS 0.07631f ; **FLOATING
C152 EAOUT.n62 VSS 0.04959f ; **FLOATING
C153 EAOUT.t8 VSS 0.07271f ; **FLOATING
C154 EAOUT.n63 VSS 0.05028f ; **FLOATING
C155 EAOUT.t9 VSS 0.07271f ; **FLOATING
C156 EAOUT.n64 VSS 0.03802f ; **FLOATING
C157 EAOUT.t10 VSS 0.07271f ; **FLOATING
C158 EAOUT.n65 VSS 0.05108f ; **FLOATING
C159 EAOUT.t11 VSS 0.07271f ; **FLOATING
C160 EAOUT.n66 VSS 0.04879f ; **FLOATING
C161 EAOUT.t12 VSS 0.07271f ; **FLOATING
C162 EAOUT.n67 VSS 0.04902f ; **FLOATING
C163 EAOUT.t13 VSS 0.07271f ; **FLOATING
C164 EAOUT.n68 VSS 0.05085f ; **FLOATING
C165 EAOUT.t14 VSS 0.07271f ; **FLOATING
C166 EAOUT.n69 VSS 0.03802f ; **FLOATING
C167 EAOUT.t15 VSS 0.07271f ; **FLOATING
C168 EAOUT.n70 VSS 0.05051f ; **FLOATING
C169 EAOUT.t16 VSS 0.07271f ; **FLOATING
C170 EAOUT.n71 VSS 0.04936f ; **FLOATING
C171 EAOUT.t17 VSS 0.07271f ; **FLOATING
C172 EAOUT.n72 VSS 0.03802f ; **FLOATING
C173 EAOUT.t18 VSS 0.07271f ; **FLOATING
C174 EAOUT.n73 VSS 0.05131f ; **FLOATING
C175 EAOUT.t19 VSS 0.07271f ; **FLOATING
C176 EAOUT.n74 VSS 0.03802f ; **FLOATING
C177 EAOUT.t20 VSS 0.07271f ; **FLOATING
C178 EAOUT.n75 VSS 0.04993f ; **FLOATING
C179 EAOUT.t21 VSS 0.07271f ; **FLOATING
C180 EAOUT.n76 VSS 0.04993f ; **FLOATING
C181 EAOUT.t22 VSS 0.07271f ; **FLOATING
C182 EAOUT.n77 VSS 0.03802f ; **FLOATING
C183 EAOUT.t23 VSS 0.07271f ; **FLOATING
C184 EAOUT.n78 VSS 0.05131f ; **FLOATING
C185 EAOUT.t24 VSS 0.07271f ; **FLOATING
C186 EAOUT.n79 VSS 0.03802f ; **FLOATING
C187 EAOUT.t25 VSS 0.07271f ; **FLOATING
C188 EAOUT.n80 VSS 0.04936f ; **FLOATING
C189 EAOUT.t26 VSS 0.07271f ; **FLOATING
C190 EAOUT.n81 VSS 0.05051f ; **FLOATING
C191 EAOUT.t27 VSS 0.07271f ; **FLOATING
C192 EAOUT.n82 VSS 0.03802f ; **FLOATING
C193 EAOUT.t28 VSS 0.07271f ; **FLOATING
C194 EAOUT.n83 VSS 0.05085f ; **FLOATING
C195 EAOUT.t29 VSS 0.07271f ; **FLOATING
C196 EAOUT.n84 VSS 0.04902f ; **FLOATING
C197 EAOUT.t30 VSS 0.07271f ; **FLOATING
C198 EAOUT.n85 VSS 0.04879f ; **FLOATING
C199 EAOUT.t31 VSS 0.07271f ; **FLOATING
C200 EAOUT.n86 VSS 0.05108f ; **FLOATING
C201 EAOUT.t32 VSS 0.07271f ; **FLOATING
C202 EAOUT.n87 VSS 0.03802f ; **FLOATING
C203 EAOUT.t33 VSS 0.07271f ; **FLOATING
C204 EAOUT.n88 VSS 0.05028f ; **FLOATING
C205 EAOUT.t34 VSS 0.07271f ; **FLOATING
C206 EAOUT.n89 VSS 0.04959f ; **FLOATING
C207 EAOUT.t35 VSS 0.07271f ; **FLOATING
C208 EAOUT.n90 VSS 0.04461f ; **FLOATING
C209 EAOUT.n91 VSS 0.11104f ; **FLOATING
C210 EAOUT.n92 VSS 0.04396f ; **FLOATING
C211 EAOUT.n93 VSS 0.08348f ; **FLOATING
C212 EAOUT.n94 VSS 0.02566f ; **FLOATING
C213 EAOUT.n95 VSS 0.02566f ; **FLOATING
C214 EAOUT.n96 VSS 0.02566f ; **FLOATING
C215 EAOUT.n97 VSS 0.02566f ; **FLOATING
C216 EAOUT.n98 VSS 0.02566f ; **FLOATING
C217 EAOUT.n99 VSS 0.02566f ; **FLOATING
C218 EAOUT.n100 VSS 0.02566f ; **FLOATING
C219 EAOUT.n101 VSS 0.02566f ; **FLOATING
C220 EAOUT.n102 VSS 0.02566f ; **FLOATING
C221 EAOUT.n103 VSS 0.02566f ; **FLOATING
C222 EAOUT.n104 VSS 0.02566f ; **FLOATING
C223 EAOUT.n105 VSS 0.02566f ; **FLOATING
C224 EAOUT.n106 VSS 0.02566f ; **FLOATING
C225 EAOUT.n107 VSS 0.02566f ; **FLOATING
C226 EAOUT.n108 VSS 0.02566f ; **FLOATING
C227 EAOUT.n109 VSS 0.02566f ; **FLOATING
C228 EAOUT.n110 VSS 0.02566f ; **FLOATING
C229 EAOUT.n111 VSS 0.02566f ; **FLOATING
C230 EAOUT.n112 VSS 0.02566f ; **FLOATING
C231 EAOUT.n113 VSS 0.02566f ; **FLOATING
C232 EAOUT.n114 VSS 0.02566f ; **FLOATING
C233 EAOUT.n115 VSS 0.02566f ; **FLOATING
C234 EAOUT.n116 VSS 0.02566f ; **FLOATING
C235 EAOUT.n117 VSS 0.02566f ; **FLOATING
C236 EAOUT.n118 VSS 0.02566f ; **FLOATING
C237 EAOUT.n119 VSS 0.02566f ; **FLOATING
C238 EAOUT.n120 VSS 0.02566f ; **FLOATING
C239 EAOUT.n121 VSS 0.02566f ; **FLOATING
C240 EAOUT.n122 VSS 0.02566f ; **FLOATING
C241 EAOUT.n123 VSS 0.02566f ; **FLOATING
C242 EAOUT.n124 VSS 0.02566f ; **FLOATING
C243 EAOUT.n125 VSS 0.02566f ; **FLOATING
C244 EAOUT.n126 VSS 0.02566f ; **FLOATING
C245 EAOUT.n127 VSS 0.02566f ; **FLOATING
C246 EAOUT.n128 VSS 0.02566f ; **FLOATING
C247 EAOUT.n129 VSS 0.02566f ; **FLOATING
C248 EAOUT.n130 VSS 0.01054f ; **FLOATING
C249 EAOUT.n131 VSS 0.01054f ; **FLOATING
C250 EAOUT.n132 VSS 0.01054f ; **FLOATING
C251 EAOUT.n133 VSS 0.01054f ; **FLOATING
C252 EAOUT.n134 VSS 0.01054f ; **FLOATING
C253 EAOUT.n135 VSS 0.01054f ; **FLOATING
C254 EAOUT.n136 VSS 0.01054f ; **FLOATING
C255 EAOUT.n137 VSS 0.01054f ; **FLOATING
C256 EAOUT.n138 VSS 0.01054f ; **FLOATING
C257 EAOUT.n139 VSS 0.01054f ; **FLOATING
C258 EAOUT.n140 VSS 0.01054f ; **FLOATING
C259 EAOUT.n141 VSS 0.01054f ; **FLOATING
C260 EAOUT.n142 VSS 0.01054f ; **FLOATING
C261 EAOUT.n143 VSS 0.01054f ; **FLOATING
C262 EAOUT.n144 VSS 0.01054f ; **FLOATING
C263 EAOUT.n145 VSS 0.01054f ; **FLOATING
C264 EAOUT.n146 VSS 0.01054f ; **FLOATING
C265 EAOUT.n147 VSS 0.01054f ; **FLOATING
C266 EAOUT.t216 VSS 0.07894f ; **FLOATING
C267 EAOUT.n148 VSS 0.04959f ; **FLOATING
C268 EAOUT.t215 VSS 0.07271f ; **FLOATING
C269 EAOUT.n149 VSS 0.05028f ; **FLOATING
C270 EAOUT.t214 VSS 0.07271f ; **FLOATING
C271 EAOUT.n150 VSS 0.03802f ; **FLOATING
C272 EAOUT.t213 VSS 0.07271f ; **FLOATING
C273 EAOUT.n151 VSS 0.05108f ; **FLOATING
C274 EAOUT.t212 VSS 0.07271f ; **FLOATING
C275 EAOUT.n152 VSS 0.04879f ; **FLOATING
C276 EAOUT.t211 VSS 0.07271f ; **FLOATING
C277 EAOUT.n153 VSS 0.04902f ; **FLOATING
C278 EAOUT.t210 VSS 0.07271f ; **FLOATING
C279 EAOUT.n154 VSS 0.05085f ; **FLOATING
C280 EAOUT.t209 VSS 0.07271f ; **FLOATING
C281 EAOUT.n155 VSS 0.03802f ; **FLOATING
C282 EAOUT.t208 VSS 0.07271f ; **FLOATING
C283 EAOUT.n156 VSS 0.05051f ; **FLOATING
C284 EAOUT.t207 VSS 0.07271f ; **FLOATING
C285 EAOUT.n157 VSS 0.04936f ; **FLOATING
C286 EAOUT.t206 VSS 0.07271f ; **FLOATING
C287 EAOUT.n158 VSS 0.03802f ; **FLOATING
C288 EAOUT.t205 VSS 0.07271f ; **FLOATING
C289 EAOUT.n159 VSS 0.05131f ; **FLOATING
C290 EAOUT.t204 VSS 0.07271f ; **FLOATING
C291 EAOUT.n160 VSS 0.03802f ; **FLOATING
C292 EAOUT.t203 VSS 0.07271f ; **FLOATING
C293 EAOUT.n161 VSS 0.04993f ; **FLOATING
C294 EAOUT.t202 VSS 0.07271f ; **FLOATING
C295 EAOUT.n162 VSS 0.04993f ; **FLOATING
C296 EAOUT.t201 VSS 0.07271f ; **FLOATING
C297 EAOUT.n163 VSS 0.03802f ; **FLOATING
C298 EAOUT.t200 VSS 0.07271f ; **FLOATING
C299 EAOUT.n164 VSS 0.05131f ; **FLOATING
C300 EAOUT.t199 VSS 0.07271f ; **FLOATING
C301 EAOUT.n165 VSS 0.03802f ; **FLOATING
C302 EAOUT.t198 VSS 0.07271f ; **FLOATING
C303 EAOUT.n166 VSS 0.04936f ; **FLOATING
C304 EAOUT.t197 VSS 0.07271f ; **FLOATING
C305 EAOUT.n167 VSS 0.05051f ; **FLOATING
C306 EAOUT.t196 VSS 0.07271f ; **FLOATING
C307 EAOUT.n168 VSS 0.03802f ; **FLOATING
C308 EAOUT.t195 VSS 0.07271f ; **FLOATING
C309 EAOUT.n169 VSS 0.05085f ; **FLOATING
C310 EAOUT.t194 VSS 0.07271f ; **FLOATING
C311 EAOUT.n170 VSS 0.04902f ; **FLOATING
C312 EAOUT.t193 VSS 0.07271f ; **FLOATING
C313 EAOUT.n171 VSS 0.04879f ; **FLOATING
C314 EAOUT.t192 VSS 0.07271f ; **FLOATING
C315 EAOUT.n172 VSS 0.05108f ; **FLOATING
C316 EAOUT.t191 VSS 0.07271f ; **FLOATING
C317 EAOUT.n173 VSS 0.03802f ; **FLOATING
C318 EAOUT.t190 VSS 0.07271f ; **FLOATING
C319 EAOUT.n174 VSS 0.05028f ; **FLOATING
C320 EAOUT.t189 VSS 0.07271f ; **FLOATING
C321 EAOUT.n175 VSS 0.04959f ; **FLOATING
C322 EAOUT.t188 VSS 0.07271f ; **FLOATING
C323 EAOUT.t187 VSS 0.07631f ; **FLOATING
C324 EAOUT.n176 VSS 0.04461f ; **FLOATING
C325 EAOUT.n177 VSS 0.0726f ; **FLOATING
C326 EAOUT.n178 VSS 0.05786f ; **FLOATING
C327 EAOUT.n179 VSS 0.02566f ; **FLOATING
C328 EAOUT.n180 VSS 0.02566f ; **FLOATING
C329 EAOUT.n181 VSS 0.02566f ; **FLOATING
C330 EAOUT.n182 VSS 0.02566f ; **FLOATING
C331 EAOUT.n183 VSS 0.02566f ; **FLOATING
C332 EAOUT.n184 VSS 0.02566f ; **FLOATING
C333 EAOUT.n185 VSS 0.02566f ; **FLOATING
C334 EAOUT.n186 VSS 0.02566f ; **FLOATING
C335 EAOUT.n187 VSS 0.02566f ; **FLOATING
C336 EAOUT.n188 VSS 0.02566f ; **FLOATING
C337 EAOUT.n189 VSS 0.02566f ; **FLOATING
C338 EAOUT.n190 VSS 0.02566f ; **FLOATING
C339 EAOUT.n191 VSS 0.02566f ; **FLOATING
C340 EAOUT.n192 VSS 0.02566f ; **FLOATING
C341 EAOUT.n193 VSS 0.02566f ; **FLOATING
C342 EAOUT.n194 VSS 0.02566f ; **FLOATING
C343 EAOUT.n195 VSS 0.02566f ; **FLOATING
C344 EAOUT.n196 VSS 0.02566f ; **FLOATING
C345 EAOUT.n197 VSS 0.02566f ; **FLOATING
C346 EAOUT.n198 VSS 0.02566f ; **FLOATING
C347 EAOUT.n199 VSS 0.02566f ; **FLOATING
C348 EAOUT.n200 VSS 0.02566f ; **FLOATING
C349 EAOUT.n201 VSS 0.02566f ; **FLOATING
C350 EAOUT.n202 VSS 0.02566f ; **FLOATING
C351 EAOUT.n203 VSS 0.02566f ; **FLOATING
C352 EAOUT.n204 VSS 0.02566f ; **FLOATING
C353 EAOUT.n205 VSS 0.02566f ; **FLOATING
C354 EAOUT.n206 VSS 0.02566f ; **FLOATING
C355 EAOUT.n207 VSS 0.02566f ; **FLOATING
C356 EAOUT.n208 VSS 0.02566f ; **FLOATING
C357 EAOUT.n209 VSS 0.02566f ; **FLOATING
C358 EAOUT.n210 VSS 0.02566f ; **FLOATING
C359 EAOUT.n211 VSS 0.02566f ; **FLOATING
C360 EAOUT.n212 VSS 0.02566f ; **FLOATING
C361 EAOUT.n213 VSS 0.02566f ; **FLOATING
C362 EAOUT.n214 VSS 0.02566f ; **FLOATING
C363 EAOUT.n215 VSS 0.08348f ; **FLOATING
C364 EAOUT.n216 VSS 0.04396f ; **FLOATING
C365 EAOUT.t186 VSS 0.07894f ; **FLOATING
C366 EAOUT.n217 VSS 0.01054f ; **FLOATING
C367 EAOUT.n218 VSS 0.01054f ; **FLOATING
C368 EAOUT.n219 VSS 0.01054f ; **FLOATING
C369 EAOUT.n220 VSS 0.01054f ; **FLOATING
C370 EAOUT.n221 VSS 0.01054f ; **FLOATING
C371 EAOUT.n222 VSS 0.01054f ; **FLOATING
C372 EAOUT.n223 VSS 0.01054f ; **FLOATING
C373 EAOUT.n224 VSS 0.01054f ; **FLOATING
C374 EAOUT.n225 VSS 0.01054f ; **FLOATING
C375 EAOUT.n226 VSS 0.01054f ; **FLOATING
C376 EAOUT.n227 VSS 0.01054f ; **FLOATING
C377 EAOUT.n228 VSS 0.01054f ; **FLOATING
C378 EAOUT.n229 VSS 0.01054f ; **FLOATING
C379 EAOUT.n230 VSS 0.01054f ; **FLOATING
C380 EAOUT.n231 VSS 0.01054f ; **FLOATING
C381 EAOUT.n232 VSS 0.01054f ; **FLOATING
C382 EAOUT.n233 VSS 0.01054f ; **FLOATING
C383 EAOUT.n234 VSS 0.01054f ; **FLOATING
C384 EAOUT.n235 VSS 0.04461f ; **FLOATING
C385 EAOUT.t157 VSS 0.07631f ; **FLOATING
C386 EAOUT.n236 VSS 0.04959f ; **FLOATING
C387 EAOUT.t158 VSS 0.07271f ; **FLOATING
C388 EAOUT.n237 VSS 0.05028f ; **FLOATING
C389 EAOUT.t159 VSS 0.07271f ; **FLOATING
C390 EAOUT.n238 VSS 0.03802f ; **FLOATING
C391 EAOUT.t160 VSS 0.07271f ; **FLOATING
C392 EAOUT.n239 VSS 0.05108f ; **FLOATING
C393 EAOUT.t161 VSS 0.07271f ; **FLOATING
C394 EAOUT.n240 VSS 0.04879f ; **FLOATING
C395 EAOUT.t162 VSS 0.07271f ; **FLOATING
C396 EAOUT.n241 VSS 0.04902f ; **FLOATING
C397 EAOUT.t163 VSS 0.07271f ; **FLOATING
C398 EAOUT.n242 VSS 0.05085f ; **FLOATING
C399 EAOUT.t164 VSS 0.07271f ; **FLOATING
C400 EAOUT.n243 VSS 0.03802f ; **FLOATING
C401 EAOUT.t165 VSS 0.07271f ; **FLOATING
C402 EAOUT.n244 VSS 0.05051f ; **FLOATING
C403 EAOUT.t166 VSS 0.07271f ; **FLOATING
C404 EAOUT.n245 VSS 0.04936f ; **FLOATING
C405 EAOUT.t167 VSS 0.07271f ; **FLOATING
C406 EAOUT.n246 VSS 0.03802f ; **FLOATING
C407 EAOUT.t168 VSS 0.07271f ; **FLOATING
C408 EAOUT.n247 VSS 0.05131f ; **FLOATING
C409 EAOUT.t169 VSS 0.07271f ; **FLOATING
C410 EAOUT.n248 VSS 0.03802f ; **FLOATING
C411 EAOUT.t170 VSS 0.07271f ; **FLOATING
C412 EAOUT.n249 VSS 0.04993f ; **FLOATING
C413 EAOUT.t171 VSS 0.07271f ; **FLOATING
C414 EAOUT.n250 VSS 0.04993f ; **FLOATING
C415 EAOUT.t172 VSS 0.07271f ; **FLOATING
C416 EAOUT.n251 VSS 0.03802f ; **FLOATING
C417 EAOUT.t173 VSS 0.07271f ; **FLOATING
C418 EAOUT.n252 VSS 0.05131f ; **FLOATING
C419 EAOUT.t174 VSS 0.07271f ; **FLOATING
C420 EAOUT.n253 VSS 0.03802f ; **FLOATING
C421 EAOUT.t175 VSS 0.07271f ; **FLOATING
C422 EAOUT.n254 VSS 0.04936f ; **FLOATING
C423 EAOUT.t176 VSS 0.07271f ; **FLOATING
C424 EAOUT.n255 VSS 0.05051f ; **FLOATING
C425 EAOUT.t177 VSS 0.07271f ; **FLOATING
C426 EAOUT.n256 VSS 0.03802f ; **FLOATING
C427 EAOUT.t178 VSS 0.07271f ; **FLOATING
C428 EAOUT.n257 VSS 0.05085f ; **FLOATING
C429 EAOUT.t179 VSS 0.07271f ; **FLOATING
C430 EAOUT.n258 VSS 0.04902f ; **FLOATING
C431 EAOUT.t180 VSS 0.07271f ; **FLOATING
C432 EAOUT.n259 VSS 0.04879f ; **FLOATING
C433 EAOUT.t181 VSS 0.07271f ; **FLOATING
C434 EAOUT.n260 VSS 0.05108f ; **FLOATING
C435 EAOUT.t182 VSS 0.07271f ; **FLOATING
C436 EAOUT.n261 VSS 0.03802f ; **FLOATING
C437 EAOUT.t183 VSS 0.07271f ; **FLOATING
C438 EAOUT.n262 VSS 0.05028f ; **FLOATING
C439 EAOUT.t184 VSS 0.07271f ; **FLOATING
C440 EAOUT.n263 VSS 0.04959f ; **FLOATING
C441 EAOUT.t185 VSS 0.07271f ; **FLOATING
C442 EAOUT.n264 VSS 0.20667f ; **FLOATING
C443 EAOUT.n265 VSS 0.05786f ; **FLOATING
C444 EAOUT.n266 VSS 0.02566f ; **FLOATING
C445 EAOUT.n267 VSS 0.02566f ; **FLOATING
C446 EAOUT.n268 VSS 0.02566f ; **FLOATING
C447 EAOUT.n269 VSS 0.02566f ; **FLOATING
C448 EAOUT.n270 VSS 0.02566f ; **FLOATING
C449 EAOUT.n271 VSS 0.02566f ; **FLOATING
C450 EAOUT.n272 VSS 0.02566f ; **FLOATING
C451 EAOUT.n273 VSS 0.02566f ; **FLOATING
C452 EAOUT.n274 VSS 0.02566f ; **FLOATING
C453 EAOUT.n275 VSS 0.02566f ; **FLOATING
C454 EAOUT.n276 VSS 0.02566f ; **FLOATING
C455 EAOUT.n277 VSS 0.02566f ; **FLOATING
C456 EAOUT.n278 VSS 0.02566f ; **FLOATING
C457 EAOUT.n279 VSS 0.02566f ; **FLOATING
C458 EAOUT.n280 VSS 0.02566f ; **FLOATING
C459 EAOUT.n281 VSS 0.02566f ; **FLOATING
C460 EAOUT.n282 VSS 0.02566f ; **FLOATING
C461 EAOUT.n283 VSS 0.02566f ; **FLOATING
C462 EAOUT.n284 VSS 0.02566f ; **FLOATING
C463 EAOUT.n285 VSS 0.02566f ; **FLOATING
C464 EAOUT.n286 VSS 0.02566f ; **FLOATING
C465 EAOUT.n287 VSS 0.02566f ; **FLOATING
C466 EAOUT.n288 VSS 0.02566f ; **FLOATING
C467 EAOUT.n289 VSS 0.02566f ; **FLOATING
C468 EAOUT.n290 VSS 0.02566f ; **FLOATING
C469 EAOUT.n291 VSS 0.02566f ; **FLOATING
C470 EAOUT.n292 VSS 0.02566f ; **FLOATING
C471 EAOUT.n293 VSS 0.02566f ; **FLOATING
C472 EAOUT.n294 VSS 0.02566f ; **FLOATING
C473 EAOUT.n295 VSS 0.02566f ; **FLOATING
C474 EAOUT.n296 VSS 0.02566f ; **FLOATING
C475 EAOUT.n297 VSS 0.02566f ; **FLOATING
C476 EAOUT.n298 VSS 0.02566f ; **FLOATING
C477 EAOUT.n299 VSS 0.02566f ; **FLOATING
C478 EAOUT.n300 VSS 0.02566f ; **FLOATING
C479 EAOUT.n301 VSS 0.02566f ; **FLOATING
C480 EAOUT.n302 VSS 0.08348f ; **FLOATING
C481 EAOUT.n303 VSS 0.04396f ; **FLOATING
C482 EAOUT.t156 VSS 0.07894f ; **FLOATING
C483 EAOUT.n304 VSS 0.01054f ; **FLOATING
C484 EAOUT.n305 VSS 0.01054f ; **FLOATING
C485 EAOUT.n306 VSS 0.01054f ; **FLOATING
C486 EAOUT.n307 VSS 0.01054f ; **FLOATING
C487 EAOUT.n308 VSS 0.01054f ; **FLOATING
C488 EAOUT.n309 VSS 0.01054f ; **FLOATING
C489 EAOUT.n310 VSS 0.01054f ; **FLOATING
C490 EAOUT.n311 VSS 0.01054f ; **FLOATING
C491 EAOUT.n312 VSS 0.01054f ; **FLOATING
C492 EAOUT.n313 VSS 0.01054f ; **FLOATING
C493 EAOUT.n314 VSS 0.01054f ; **FLOATING
C494 EAOUT.n315 VSS 0.01054f ; **FLOATING
C495 EAOUT.n316 VSS 0.01054f ; **FLOATING
C496 EAOUT.n317 VSS 0.01054f ; **FLOATING
C497 EAOUT.n318 VSS 0.01054f ; **FLOATING
C498 EAOUT.n319 VSS 0.01054f ; **FLOATING
C499 EAOUT.n320 VSS 0.01054f ; **FLOATING
C500 EAOUT.n321 VSS 0.01054f ; **FLOATING
C501 EAOUT.n322 VSS 0.04461f ; **FLOATING
C502 EAOUT.t127 VSS 0.07631f ; **FLOATING
C503 EAOUT.n323 VSS 0.04959f ; **FLOATING
C504 EAOUT.t128 VSS 0.07271f ; **FLOATING
C505 EAOUT.n324 VSS 0.05028f ; **FLOATING
C506 EAOUT.t129 VSS 0.07271f ; **FLOATING
C507 EAOUT.n325 VSS 0.03802f ; **FLOATING
C508 EAOUT.t130 VSS 0.07271f ; **FLOATING
C509 EAOUT.n326 VSS 0.05108f ; **FLOATING
C510 EAOUT.t131 VSS 0.07271f ; **FLOATING
C511 EAOUT.n327 VSS 0.04879f ; **FLOATING
C512 EAOUT.t132 VSS 0.07271f ; **FLOATING
C513 EAOUT.n328 VSS 0.04902f ; **FLOATING
C514 EAOUT.t133 VSS 0.07271f ; **FLOATING
C515 EAOUT.n329 VSS 0.05085f ; **FLOATING
C516 EAOUT.t134 VSS 0.07271f ; **FLOATING
C517 EAOUT.n330 VSS 0.03802f ; **FLOATING
C518 EAOUT.t135 VSS 0.07271f ; **FLOATING
C519 EAOUT.n331 VSS 0.05051f ; **FLOATING
C520 EAOUT.t136 VSS 0.07271f ; **FLOATING
C521 EAOUT.n332 VSS 0.04936f ; **FLOATING
C522 EAOUT.t137 VSS 0.07271f ; **FLOATING
C523 EAOUT.n333 VSS 0.03802f ; **FLOATING
C524 EAOUT.t138 VSS 0.07271f ; **FLOATING
C525 EAOUT.n334 VSS 0.05131f ; **FLOATING
C526 EAOUT.t139 VSS 0.07271f ; **FLOATING
C527 EAOUT.n335 VSS 0.03802f ; **FLOATING
C528 EAOUT.t140 VSS 0.07271f ; **FLOATING
C529 EAOUT.n336 VSS 0.04993f ; **FLOATING
C530 EAOUT.t141 VSS 0.07271f ; **FLOATING
C531 EAOUT.n337 VSS 0.04993f ; **FLOATING
C532 EAOUT.t142 VSS 0.07271f ; **FLOATING
C533 EAOUT.n338 VSS 0.03802f ; **FLOATING
C534 EAOUT.t143 VSS 0.07271f ; **FLOATING
C535 EAOUT.n339 VSS 0.05131f ; **FLOATING
C536 EAOUT.t144 VSS 0.07271f ; **FLOATING
C537 EAOUT.n340 VSS 0.03802f ; **FLOATING
C538 EAOUT.t145 VSS 0.07271f ; **FLOATING
C539 EAOUT.n341 VSS 0.04936f ; **FLOATING
C540 EAOUT.t146 VSS 0.07271f ; **FLOATING
C541 EAOUT.n342 VSS 0.05051f ; **FLOATING
C542 EAOUT.t147 VSS 0.07271f ; **FLOATING
C543 EAOUT.n343 VSS 0.03802f ; **FLOATING
C544 EAOUT.t148 VSS 0.07271f ; **FLOATING
C545 EAOUT.n344 VSS 0.05085f ; **FLOATING
C546 EAOUT.t149 VSS 0.07271f ; **FLOATING
C547 EAOUT.n345 VSS 0.04902f ; **FLOATING
C548 EAOUT.t150 VSS 0.07271f ; **FLOATING
C549 EAOUT.n346 VSS 0.04879f ; **FLOATING
C550 EAOUT.t151 VSS 0.07271f ; **FLOATING
C551 EAOUT.n347 VSS 0.05108f ; **FLOATING
C552 EAOUT.t152 VSS 0.07271f ; **FLOATING
C553 EAOUT.n348 VSS 0.03802f ; **FLOATING
C554 EAOUT.t153 VSS 0.07271f ; **FLOATING
C555 EAOUT.n349 VSS 0.05028f ; **FLOATING
C556 EAOUT.t154 VSS 0.07271f ; **FLOATING
C557 EAOUT.n350 VSS 0.04959f ; **FLOATING
C558 EAOUT.t155 VSS 0.07271f ; **FLOATING
C559 EAOUT.n351 VSS 0.14329f ; **FLOATING
C560 EAOUT.n352 VSS 0.05786f ; **FLOATING
C561 EAOUT.n353 VSS 0.02566f ; **FLOATING
C562 EAOUT.n354 VSS 0.02566f ; **FLOATING
C563 EAOUT.n355 VSS 0.02566f ; **FLOATING
C564 EAOUT.n356 VSS 0.02566f ; **FLOATING
C565 EAOUT.n357 VSS 0.02566f ; **FLOATING
C566 EAOUT.n358 VSS 0.02566f ; **FLOATING
C567 EAOUT.n359 VSS 0.02566f ; **FLOATING
C568 EAOUT.n360 VSS 0.02566f ; **FLOATING
C569 EAOUT.n361 VSS 0.02566f ; **FLOATING
C570 EAOUT.n362 VSS 0.02566f ; **FLOATING
C571 EAOUT.n363 VSS 0.02566f ; **FLOATING
C572 EAOUT.n364 VSS 0.02566f ; **FLOATING
C573 EAOUT.n365 VSS 0.02566f ; **FLOATING
C574 EAOUT.n366 VSS 0.02566f ; **FLOATING
C575 EAOUT.n367 VSS 0.02566f ; **FLOATING
C576 EAOUT.n368 VSS 0.02566f ; **FLOATING
C577 EAOUT.n369 VSS 0.02566f ; **FLOATING
C578 EAOUT.n370 VSS 0.02566f ; **FLOATING
C579 EAOUT.n371 VSS 0.02566f ; **FLOATING
C580 EAOUT.n372 VSS 0.02566f ; **FLOATING
C581 EAOUT.n373 VSS 0.02566f ; **FLOATING
C582 EAOUT.n374 VSS 0.02566f ; **FLOATING
C583 EAOUT.n375 VSS 0.02566f ; **FLOATING
C584 EAOUT.n376 VSS 0.02566f ; **FLOATING
C585 EAOUT.n377 VSS 0.02566f ; **FLOATING
C586 EAOUT.n378 VSS 0.02566f ; **FLOATING
C587 EAOUT.n379 VSS 0.02566f ; **FLOATING
C588 EAOUT.n380 VSS 0.02566f ; **FLOATING
C589 EAOUT.n381 VSS 0.02566f ; **FLOATING
C590 EAOUT.n382 VSS 0.02566f ; **FLOATING
C591 EAOUT.n383 VSS 0.02566f ; **FLOATING
C592 EAOUT.n384 VSS 0.02566f ; **FLOATING
C593 EAOUT.n385 VSS 0.02566f ; **FLOATING
C594 EAOUT.n386 VSS 0.02566f ; **FLOATING
C595 EAOUT.n387 VSS 0.02566f ; **FLOATING
C596 EAOUT.n388 VSS 0.02566f ; **FLOATING
C597 EAOUT.n389 VSS 0.08348f ; **FLOATING
C598 EAOUT.n390 VSS 0.04396f ; **FLOATING
C599 EAOUT.t126 VSS 0.07894f ; **FLOATING
C600 EAOUT.n391 VSS 0.01054f ; **FLOATING
C601 EAOUT.n392 VSS 0.01054f ; **FLOATING
C602 EAOUT.n393 VSS 0.01054f ; **FLOATING
C603 EAOUT.n394 VSS 0.01054f ; **FLOATING
C604 EAOUT.n395 VSS 0.01054f ; **FLOATING
C605 EAOUT.n396 VSS 0.01054f ; **FLOATING
C606 EAOUT.n397 VSS 0.01054f ; **FLOATING
C607 EAOUT.n398 VSS 0.01054f ; **FLOATING
C608 EAOUT.n399 VSS 0.01054f ; **FLOATING
C609 EAOUT.n400 VSS 0.01054f ; **FLOATING
C610 EAOUT.n401 VSS 0.01054f ; **FLOATING
C611 EAOUT.n402 VSS 0.01054f ; **FLOATING
C612 EAOUT.n403 VSS 0.01054f ; **FLOATING
C613 EAOUT.n404 VSS 0.01054f ; **FLOATING
C614 EAOUT.n405 VSS 0.01054f ; **FLOATING
C615 EAOUT.n406 VSS 0.01054f ; **FLOATING
C616 EAOUT.n407 VSS 0.01054f ; **FLOATING
C617 EAOUT.n408 VSS 0.01054f ; **FLOATING
C618 EAOUT.n409 VSS 0.04461f ; **FLOATING
C619 EAOUT.t97 VSS 0.07631f ; **FLOATING
C620 EAOUT.n410 VSS 0.04959f ; **FLOATING
C621 EAOUT.t98 VSS 0.07271f ; **FLOATING
C622 EAOUT.n411 VSS 0.05028f ; **FLOATING
C623 EAOUT.t99 VSS 0.07271f ; **FLOATING
C624 EAOUT.n412 VSS 0.03802f ; **FLOATING
C625 EAOUT.t100 VSS 0.07271f ; **FLOATING
C626 EAOUT.n413 VSS 0.05108f ; **FLOATING
C627 EAOUT.t101 VSS 0.07271f ; **FLOATING
C628 EAOUT.n414 VSS 0.04879f ; **FLOATING
C629 EAOUT.t102 VSS 0.07271f ; **FLOATING
C630 EAOUT.n415 VSS 0.04902f ; **FLOATING
C631 EAOUT.t103 VSS 0.07271f ; **FLOATING
C632 EAOUT.n416 VSS 0.05085f ; **FLOATING
C633 EAOUT.t104 VSS 0.07271f ; **FLOATING
C634 EAOUT.n417 VSS 0.03802f ; **FLOATING
C635 EAOUT.t105 VSS 0.07271f ; **FLOATING
C636 EAOUT.n418 VSS 0.05051f ; **FLOATING
C637 EAOUT.t106 VSS 0.07271f ; **FLOATING
C638 EAOUT.n419 VSS 0.04936f ; **FLOATING
C639 EAOUT.t107 VSS 0.07271f ; **FLOATING
C640 EAOUT.n420 VSS 0.03802f ; **FLOATING
C641 EAOUT.t108 VSS 0.07271f ; **FLOATING
C642 EAOUT.n421 VSS 0.05131f ; **FLOATING
C643 EAOUT.t109 VSS 0.07271f ; **FLOATING
C644 EAOUT.n422 VSS 0.03802f ; **FLOATING
C645 EAOUT.t110 VSS 0.07271f ; **FLOATING
C646 EAOUT.n423 VSS 0.04993f ; **FLOATING
C647 EAOUT.t111 VSS 0.07271f ; **FLOATING
C648 EAOUT.n424 VSS 0.04993f ; **FLOATING
C649 EAOUT.t112 VSS 0.07271f ; **FLOATING
C650 EAOUT.n425 VSS 0.03802f ; **FLOATING
C651 EAOUT.t113 VSS 0.07271f ; **FLOATING
C652 EAOUT.n426 VSS 0.05131f ; **FLOATING
C653 EAOUT.t114 VSS 0.07271f ; **FLOATING
C654 EAOUT.n427 VSS 0.03802f ; **FLOATING
C655 EAOUT.t115 VSS 0.07271f ; **FLOATING
C656 EAOUT.n428 VSS 0.04936f ; **FLOATING
C657 EAOUT.t116 VSS 0.07271f ; **FLOATING
C658 EAOUT.n429 VSS 0.05051f ; **FLOATING
C659 EAOUT.t117 VSS 0.07271f ; **FLOATING
C660 EAOUT.n430 VSS 0.03802f ; **FLOATING
C661 EAOUT.t118 VSS 0.07271f ; **FLOATING
C662 EAOUT.n431 VSS 0.05085f ; **FLOATING
C663 EAOUT.t119 VSS 0.07271f ; **FLOATING
C664 EAOUT.n432 VSS 0.04902f ; **FLOATING
C665 EAOUT.t120 VSS 0.07271f ; **FLOATING
C666 EAOUT.n433 VSS 0.04879f ; **FLOATING
C667 EAOUT.t121 VSS 0.07271f ; **FLOATING
C668 EAOUT.n434 VSS 0.05108f ; **FLOATING
C669 EAOUT.t122 VSS 0.07271f ; **FLOATING
C670 EAOUT.n435 VSS 0.03802f ; **FLOATING
C671 EAOUT.t123 VSS 0.07271f ; **FLOATING
C672 EAOUT.n436 VSS 0.05028f ; **FLOATING
C673 EAOUT.t124 VSS 0.07271f ; **FLOATING
C674 EAOUT.n437 VSS 0.04959f ; **FLOATING
C675 EAOUT.t125 VSS 0.07271f ; **FLOATING
C676 EAOUT.n438 VSS 0.14329f ; **FLOATING
C677 EAOUT.n439 VSS 0.05786f ; **FLOATING
C678 EAOUT.n440 VSS 0.02566f ; **FLOATING
C679 EAOUT.n441 VSS 0.02566f ; **FLOATING
C680 EAOUT.n442 VSS 0.02566f ; **FLOATING
C681 EAOUT.n443 VSS 0.02566f ; **FLOATING
C682 EAOUT.n444 VSS 0.02566f ; **FLOATING
C683 EAOUT.n445 VSS 0.02566f ; **FLOATING
C684 EAOUT.n446 VSS 0.02566f ; **FLOATING
C685 EAOUT.n447 VSS 0.02566f ; **FLOATING
C686 EAOUT.n448 VSS 0.02566f ; **FLOATING
C687 EAOUT.n449 VSS 0.02566f ; **FLOATING
C688 EAOUT.n450 VSS 0.02566f ; **FLOATING
C689 EAOUT.n451 VSS 0.02566f ; **FLOATING
C690 EAOUT.n452 VSS 0.02566f ; **FLOATING
C691 EAOUT.n453 VSS 0.02566f ; **FLOATING
C692 EAOUT.n454 VSS 0.02566f ; **FLOATING
C693 EAOUT.n455 VSS 0.02566f ; **FLOATING
C694 EAOUT.n456 VSS 0.02566f ; **FLOATING
C695 EAOUT.n457 VSS 0.02566f ; **FLOATING
C696 EAOUT.n458 VSS 0.02566f ; **FLOATING
C697 EAOUT.n459 VSS 0.02566f ; **FLOATING
C698 EAOUT.n460 VSS 0.02566f ; **FLOATING
C699 EAOUT.n461 VSS 0.02566f ; **FLOATING
C700 EAOUT.n462 VSS 0.02566f ; **FLOATING
C701 EAOUT.n463 VSS 0.02566f ; **FLOATING
C702 EAOUT.n464 VSS 0.02566f ; **FLOATING
C703 EAOUT.n465 VSS 0.02566f ; **FLOATING
C704 EAOUT.n466 VSS 0.02566f ; **FLOATING
C705 EAOUT.n467 VSS 0.02566f ; **FLOATING
C706 EAOUT.n468 VSS 0.02566f ; **FLOATING
C707 EAOUT.n469 VSS 0.02566f ; **FLOATING
C708 EAOUT.n470 VSS 0.02566f ; **FLOATING
C709 EAOUT.n471 VSS 0.02566f ; **FLOATING
C710 EAOUT.n472 VSS 0.02566f ; **FLOATING
C711 EAOUT.n473 VSS 0.02566f ; **FLOATING
C712 EAOUT.n474 VSS 0.02566f ; **FLOATING
C713 EAOUT.n475 VSS 0.02566f ; **FLOATING
C714 EAOUT.n476 VSS 0.08348f ; **FLOATING
C715 EAOUT.n477 VSS 0.04396f ; **FLOATING
C716 EAOUT.t96 VSS 0.07894f ; **FLOATING
C717 EAOUT.n478 VSS 0.01054f ; **FLOATING
C718 EAOUT.n479 VSS 0.01054f ; **FLOATING
C719 EAOUT.n480 VSS 0.01054f ; **FLOATING
C720 EAOUT.n481 VSS 0.01054f ; **FLOATING
C721 EAOUT.n482 VSS 0.01054f ; **FLOATING
C722 EAOUT.n483 VSS 0.01054f ; **FLOATING
C723 EAOUT.n484 VSS 0.01054f ; **FLOATING
C724 EAOUT.n485 VSS 0.01054f ; **FLOATING
C725 EAOUT.n486 VSS 0.01054f ; **FLOATING
C726 EAOUT.n487 VSS 0.01054f ; **FLOATING
C727 EAOUT.n488 VSS 0.01054f ; **FLOATING
C728 EAOUT.n489 VSS 0.01054f ; **FLOATING
C729 EAOUT.n490 VSS 0.01054f ; **FLOATING
C730 EAOUT.n491 VSS 0.01054f ; **FLOATING
C731 EAOUT.n492 VSS 0.01054f ; **FLOATING
C732 EAOUT.n493 VSS 0.01054f ; **FLOATING
C733 EAOUT.n494 VSS 0.01054f ; **FLOATING
C734 EAOUT.n495 VSS 0.01054f ; **FLOATING
C735 EAOUT.n496 VSS 0.04461f ; **FLOATING
C736 EAOUT.t67 VSS 0.07631f ; **FLOATING
C737 EAOUT.n497 VSS 0.04959f ; **FLOATING
C738 EAOUT.t68 VSS 0.07271f ; **FLOATING
C739 EAOUT.n498 VSS 0.05028f ; **FLOATING
C740 EAOUT.t69 VSS 0.07271f ; **FLOATING
C741 EAOUT.n499 VSS 0.03802f ; **FLOATING
C742 EAOUT.t70 VSS 0.07271f ; **FLOATING
C743 EAOUT.n500 VSS 0.05108f ; **FLOATING
C744 EAOUT.t71 VSS 0.07271f ; **FLOATING
C745 EAOUT.n501 VSS 0.04879f ; **FLOATING
C746 EAOUT.t72 VSS 0.07271f ; **FLOATING
C747 EAOUT.n502 VSS 0.04902f ; **FLOATING
C748 EAOUT.t73 VSS 0.07271f ; **FLOATING
C749 EAOUT.n503 VSS 0.05085f ; **FLOATING
C750 EAOUT.t74 VSS 0.07271f ; **FLOATING
C751 EAOUT.n504 VSS 0.03802f ; **FLOATING
C752 EAOUT.t75 VSS 0.07271f ; **FLOATING
C753 EAOUT.n505 VSS 0.05051f ; **FLOATING
C754 EAOUT.t76 VSS 0.07271f ; **FLOATING
C755 EAOUT.n506 VSS 0.04936f ; **FLOATING
C756 EAOUT.t77 VSS 0.07271f ; **FLOATING
C757 EAOUT.n507 VSS 0.03802f ; **FLOATING
C758 EAOUT.t78 VSS 0.07271f ; **FLOATING
C759 EAOUT.n508 VSS 0.05131f ; **FLOATING
C760 EAOUT.t79 VSS 0.07271f ; **FLOATING
C761 EAOUT.n509 VSS 0.03802f ; **FLOATING
C762 EAOUT.t80 VSS 0.07271f ; **FLOATING
C763 EAOUT.n510 VSS 0.04993f ; **FLOATING
C764 EAOUT.t81 VSS 0.07271f ; **FLOATING
C765 EAOUT.n511 VSS 0.04993f ; **FLOATING
C766 EAOUT.t82 VSS 0.07271f ; **FLOATING
C767 EAOUT.n512 VSS 0.03802f ; **FLOATING
C768 EAOUT.t83 VSS 0.07271f ; **FLOATING
C769 EAOUT.n513 VSS 0.05131f ; **FLOATING
C770 EAOUT.t84 VSS 0.07271f ; **FLOATING
C771 EAOUT.n514 VSS 0.03802f ; **FLOATING
C772 EAOUT.t85 VSS 0.07271f ; **FLOATING
C773 EAOUT.n515 VSS 0.04936f ; **FLOATING
C774 EAOUT.t86 VSS 0.07271f ; **FLOATING
C775 EAOUT.n516 VSS 0.05051f ; **FLOATING
C776 EAOUT.t87 VSS 0.07271f ; **FLOATING
C777 EAOUT.n517 VSS 0.03802f ; **FLOATING
C778 EAOUT.t88 VSS 0.07271f ; **FLOATING
C779 EAOUT.n518 VSS 0.05085f ; **FLOATING
C780 EAOUT.t89 VSS 0.07271f ; **FLOATING
C781 EAOUT.n519 VSS 0.04902f ; **FLOATING
C782 EAOUT.t90 VSS 0.07271f ; **FLOATING
C783 EAOUT.n520 VSS 0.04879f ; **FLOATING
C784 EAOUT.t91 VSS 0.07271f ; **FLOATING
C785 EAOUT.n521 VSS 0.05108f ; **FLOATING
C786 EAOUT.t92 VSS 0.07271f ; **FLOATING
C787 EAOUT.n522 VSS 0.03802f ; **FLOATING
C788 EAOUT.t93 VSS 0.07271f ; **FLOATING
C789 EAOUT.n523 VSS 0.05028f ; **FLOATING
C790 EAOUT.t94 VSS 0.07271f ; **FLOATING
C791 EAOUT.n524 VSS 0.04959f ; **FLOATING
C792 EAOUT.t95 VSS 0.07271f ; **FLOATING
C793 EAOUT.n525 VSS 0.14329f ; **FLOATING
C794 EAOUT.n526 VSS 0.05786f ; **FLOATING
C795 EAOUT.n527 VSS 0.02566f ; **FLOATING
C796 EAOUT.n528 VSS 0.02566f ; **FLOATING
C797 EAOUT.n529 VSS 0.02566f ; **FLOATING
C798 EAOUT.n530 VSS 0.02566f ; **FLOATING
C799 EAOUT.n531 VSS 0.02566f ; **FLOATING
C800 EAOUT.n532 VSS 0.02566f ; **FLOATING
C801 EAOUT.n533 VSS 0.02566f ; **FLOATING
C802 EAOUT.n534 VSS 0.02566f ; **FLOATING
C803 EAOUT.n535 VSS 0.02566f ; **FLOATING
C804 EAOUT.n536 VSS 0.02566f ; **FLOATING
C805 EAOUT.n537 VSS 0.02566f ; **FLOATING
C806 EAOUT.n538 VSS 0.02566f ; **FLOATING
C807 EAOUT.n539 VSS 0.02566f ; **FLOATING
C808 EAOUT.n540 VSS 0.02566f ; **FLOATING
C809 EAOUT.n541 VSS 0.02566f ; **FLOATING
C810 EAOUT.n542 VSS 0.02566f ; **FLOATING
C811 EAOUT.n543 VSS 0.02566f ; **FLOATING
C812 EAOUT.n544 VSS 0.02566f ; **FLOATING
C813 EAOUT.n545 VSS 0.02566f ; **FLOATING
C814 EAOUT.n546 VSS 0.02566f ; **FLOATING
C815 EAOUT.n547 VSS 0.02566f ; **FLOATING
C816 EAOUT.n548 VSS 0.02566f ; **FLOATING
C817 EAOUT.n549 VSS 0.02566f ; **FLOATING
C818 EAOUT.n550 VSS 0.02566f ; **FLOATING
C819 EAOUT.n551 VSS 0.02566f ; **FLOATING
C820 EAOUT.n552 VSS 0.02566f ; **FLOATING
C821 EAOUT.n553 VSS 0.02566f ; **FLOATING
C822 EAOUT.n554 VSS 0.02566f ; **FLOATING
C823 EAOUT.n555 VSS 0.02566f ; **FLOATING
C824 EAOUT.n556 VSS 0.02566f ; **FLOATING
C825 EAOUT.n557 VSS 0.02566f ; **FLOATING
C826 EAOUT.n558 VSS 0.02566f ; **FLOATING
C827 EAOUT.n559 VSS 0.02566f ; **FLOATING
C828 EAOUT.n560 VSS 0.02566f ; **FLOATING
C829 EAOUT.n561 VSS 0.02566f ; **FLOATING
C830 EAOUT.n562 VSS 0.02566f ; **FLOATING
C831 EAOUT.n563 VSS 0.08348f ; **FLOATING
C832 EAOUT.n564 VSS 0.04396f ; **FLOATING
C833 EAOUT.t66 VSS 0.07894f ; **FLOATING
C834 EAOUT.n565 VSS 0.01054f ; **FLOATING
C835 EAOUT.n566 VSS 0.01054f ; **FLOATING
C836 EAOUT.n567 VSS 0.01054f ; **FLOATING
C837 EAOUT.n568 VSS 0.01054f ; **FLOATING
C838 EAOUT.n569 VSS 0.01054f ; **FLOATING
C839 EAOUT.n570 VSS 0.01054f ; **FLOATING
C840 EAOUT.n571 VSS 0.01054f ; **FLOATING
C841 EAOUT.n572 VSS 0.01054f ; **FLOATING
C842 EAOUT.n573 VSS 0.01054f ; **FLOATING
C843 EAOUT.n574 VSS 0.01054f ; **FLOATING
C844 EAOUT.n575 VSS 0.01054f ; **FLOATING
C845 EAOUT.n576 VSS 0.01054f ; **FLOATING
C846 EAOUT.n577 VSS 0.01054f ; **FLOATING
C847 EAOUT.n578 VSS 0.01054f ; **FLOATING
C848 EAOUT.n579 VSS 0.01054f ; **FLOATING
C849 EAOUT.n580 VSS 0.01054f ; **FLOATING
C850 EAOUT.n581 VSS 0.01054f ; **FLOATING
C851 EAOUT.n582 VSS 0.01054f ; **FLOATING
C852 EAOUT.n583 VSS 0.04461f ; **FLOATING
C853 EAOUT.t37 VSS 0.07631f ; **FLOATING
C854 EAOUT.n584 VSS 0.04959f ; **FLOATING
C855 EAOUT.t38 VSS 0.07271f ; **FLOATING
C856 EAOUT.n585 VSS 0.05028f ; **FLOATING
C857 EAOUT.t39 VSS 0.07271f ; **FLOATING
C858 EAOUT.n586 VSS 0.03802f ; **FLOATING
C859 EAOUT.t40 VSS 0.07271f ; **FLOATING
C860 EAOUT.n587 VSS 0.05108f ; **FLOATING
C861 EAOUT.t41 VSS 0.07271f ; **FLOATING
C862 EAOUT.n588 VSS 0.04879f ; **FLOATING
C863 EAOUT.t42 VSS 0.07271f ; **FLOATING
C864 EAOUT.n589 VSS 0.04902f ; **FLOATING
C865 EAOUT.t43 VSS 0.07271f ; **FLOATING
C866 EAOUT.n590 VSS 0.05085f ; **FLOATING
C867 EAOUT.t44 VSS 0.07271f ; **FLOATING
C868 EAOUT.n591 VSS 0.03802f ; **FLOATING
C869 EAOUT.t45 VSS 0.07271f ; **FLOATING
C870 EAOUT.n592 VSS 0.05051f ; **FLOATING
C871 EAOUT.t46 VSS 0.07271f ; **FLOATING
C872 EAOUT.n593 VSS 0.04936f ; **FLOATING
C873 EAOUT.t47 VSS 0.07271f ; **FLOATING
C874 EAOUT.n594 VSS 0.03802f ; **FLOATING
C875 EAOUT.t48 VSS 0.07271f ; **FLOATING
C876 EAOUT.n595 VSS 0.05131f ; **FLOATING
C877 EAOUT.t49 VSS 0.07271f ; **FLOATING
C878 EAOUT.n596 VSS 0.03802f ; **FLOATING
C879 EAOUT.t50 VSS 0.07271f ; **FLOATING
C880 EAOUT.n597 VSS 0.04993f ; **FLOATING
C881 EAOUT.t51 VSS 0.07271f ; **FLOATING
C882 EAOUT.n598 VSS 0.04993f ; **FLOATING
C883 EAOUT.t52 VSS 0.07271f ; **FLOATING
C884 EAOUT.n599 VSS 0.03802f ; **FLOATING
C885 EAOUT.t53 VSS 0.07271f ; **FLOATING
C886 EAOUT.n600 VSS 0.05131f ; **FLOATING
C887 EAOUT.t54 VSS 0.07271f ; **FLOATING
C888 EAOUT.n601 VSS 0.03802f ; **FLOATING
C889 EAOUT.t55 VSS 0.07271f ; **FLOATING
C890 EAOUT.n602 VSS 0.04936f ; **FLOATING
C891 EAOUT.t56 VSS 0.07271f ; **FLOATING
C892 EAOUT.n603 VSS 0.05051f ; **FLOATING
C893 EAOUT.t57 VSS 0.07271f ; **FLOATING
C894 EAOUT.n604 VSS 0.03802f ; **FLOATING
C895 EAOUT.t58 VSS 0.07271f ; **FLOATING
C896 EAOUT.n605 VSS 0.05085f ; **FLOATING
C897 EAOUT.t59 VSS 0.07271f ; **FLOATING
C898 EAOUT.n606 VSS 0.04902f ; **FLOATING
C899 EAOUT.t60 VSS 0.07271f ; **FLOATING
C900 EAOUT.n607 VSS 0.04879f ; **FLOATING
C901 EAOUT.t61 VSS 0.07271f ; **FLOATING
C902 EAOUT.n608 VSS 0.05108f ; **FLOATING
C903 EAOUT.t62 VSS 0.07271f ; **FLOATING
C904 EAOUT.n609 VSS 0.03802f ; **FLOATING
C905 EAOUT.t63 VSS 0.07271f ; **FLOATING
C906 EAOUT.n610 VSS 0.05028f ; **FLOATING
C907 EAOUT.t64 VSS 0.07271f ; **FLOATING
C908 EAOUT.n611 VSS 0.04959f ; **FLOATING
C909 EAOUT.t65 VSS 0.07271f ; **FLOATING
C910 EAOUT.n612 VSS 0.20667f ; **FLOATING
C911 EAOUT.n613 VSS 0.35442f ; **FLOATING
C912 EAOUT.n614 VSS 0.74201f ; **FLOATING
C913 EAOUT.t0 VSS 0.78068f ; **FLOATING
C914 EAOUT.t1 VSS 0.74061f ; **FLOATING
C915 EAOUT.n615 VSS 1.07177f ; **FLOATING
C916 EAOUT.t6 VSS 0.55619f ; **FLOATING
C917 EAOUT.n616 VSS 1.72559f ; **FLOATING
C918 EAOUT.n617 VSS 0.56165f ; **FLOATING
C919 a_3623_3336.t0 VSS 2.88023f ; **FLOATING
C920 a_3623_3336.t2 VSS 0.86387f ; **FLOATING
C921 a_3623_3336.t1 VSS 2.77798f ; **FLOATING
C922 a_3623_3336.n0 VSS 8.20452f ; **FLOATING
C923 a_25212_9686.t5 VSS 0.63767f ; **FLOATING
C924 a_25212_9686.t3 VSS 0.5519f ; **FLOATING
C925 a_25212_9686.n0 VSS 2.24192f ; **FLOATING
C926 a_25212_9686.t0 VSS 2.14075f ; **FLOATING
C927 a_25212_9686.t1 VSS 2.27271f ; **FLOATING
C928 a_25212_9686.n1 VSS 2.23012f ; **FLOATING
C929 a_25212_9686.n2 VSS 1.88268f ; **FLOATING
C930 a_25212_9686.n3 VSS 0.84602f ; **FLOATING
C931 a_25212_9686.t7 VSS 0.25401f ; **FLOATING
C932 a_25212_9686.t6 VSS 0.2559f ; **FLOATING
C933 a_25212_9686.n4 VSS 1.98283f ; **FLOATING
C934 a_25212_9686.t2 VSS 0.23333f ; **FLOATING
C935 a_25212_9686.n5 VSS 1.03087f ; **FLOATING
C936 a_25212_9686.t4 VSS 0.24637f ; **FLOATING
C937 a_25442_9686.t0 VSS 0.64547f ; **FLOATING
C938 a_25442_9686.t1 VSS 0.60712f ; **FLOATING
C939 a_25442_9686.n0 VSS 1.69666f ; **FLOATING
C940 a_25442_9686.t3 VSS 1.19572f ; **FLOATING
C941 a_25442_9686.t5 VSS 1.32805f ; **FLOATING
C942 a_25442_9686.n1 VSS 1.98411f ; **FLOATING
C943 a_25442_9686.n2 VSS 3.31664f ; **FLOATING
C944 a_25442_9686.n3 VSS 2.74916f ; **FLOATING
C945 a_25442_9686.t7 VSS 2.38305f ; **FLOATING
C946 a_25442_9686.t6 VSS 2.4386f ; **FLOATING
C947 a_25442_9686.n4 VSS 2.01993f ; **FLOATING
C948 a_25442_9686.n5 VSS 2.93532f ; **FLOATING
C949 a_25442_9686.t2 VSS 2.22705f ; **FLOATING
C950 a_25442_9686.t4 VSS 2.52646f ; **FLOATING
C951 a_25710_9686.t1 VSS 1.13067f ; **FLOATING
C952 a_25710_9686.t2 VSS 1.14845f ; **FLOATING
C953 a_25710_9686.n0 VSS 4.91489f ; **FLOATING
C954 a_25710_9686.n1 VSS 5.60966f ; **FLOATING
C955 a_25710_9686.t0 VSS 2.42568f ; **FLOATING
C956 a_25710_9686.t3 VSS 2.20656f ; **FLOATING
C957 a_18233_3337.t3 VSS 0.26906f ; **FLOATING
C958 a_18233_3337.t1 VSS 0.25224f ; **FLOATING
C959 a_18233_3337.n0 VSS 0.61581f ; **FLOATING
C960 a_18233_3337.n1 VSS 1.74071f ; **FLOATING
C961 a_18233_3337.n2 VSS 0.37645f ; **FLOATING
C962 a_18233_3337.t7 VSS 0.12594f ; **FLOATING
C963 a_18233_3337.t6 VSS 0.12691f ; **FLOATING
C964 a_18233_3337.n3 VSS 0.29035f ; **FLOATING
C965 a_18233_3337.t0 VSS 0.11616f ; **FLOATING
C966 a_18233_3337.n4 VSS 0.45395f ; **FLOATING
C967 a_18233_3337.t2 VSS 0.12271f ; **FLOATING
C968 a_18233_3337.t4 VSS 0.2152f ; **FLOATING
C969 a_18233_3337.n5 VSS 1.20144f ; **FLOATING
C970 a_18233_3337.t5 VSS 0.43826f ; **FLOATING
C971 a_28055_3556.t0 VSS 0.45105f ; **FLOATING
C972 a_28055_3556.n0 VSS 1.01996f ; **FLOATING
C973 a_28055_3556.t1 VSS 0.47547f ; **FLOATING
C974 a_28055_3556.t2 VSS 1.75138f ; **FLOATING
C975 a_28055_3556.t3 VSS 1.70459f ; **FLOATING
C976 a_28055_3556.n1 VSS 1.13704f ; **FLOATING
C977 a_28055_3556.n2 VSS 1.28744f ; **FLOATING
C978 a_28055_3556.t5 VSS 1.68864f ; **FLOATING
C979 a_28055_3556.n3 VSS 1.23343f ; **FLOATING
C980 a_28055_3556.t4 VSS 1.92872f ; **FLOATING
C981 VIN.t269 VSS 1.32935f ; **FLOATING
C982 VIN.n0 VSS 4.95452f ; **FLOATING
C983 VIN.t262 VSS 0.60211f ; **FLOATING
C984 VIN.n1 VSS 1.4273f ; **FLOATING
C985 VIN.t264 VSS 0.46278f ; **FLOATING
C986 VIN.n2 VSS 0.31966f ; **FLOATING
C987 VIN.t266 VSS 0.47031f ; **FLOATING
C988 VIN.n3 VSS 2.15612f ; **FLOATING
C989 VIN.t172 VSS 0.61548f ; **FLOATING
C990 VIN.n4 VSS 0.02058f ; **FLOATING
C991 VIN.n5 VSS 0.02525f ; **FLOATING
C992 VIN.n6 VSS 0.2168f ; **FLOATING
C993 VIN.n7 VSS 0.02533f ; **FLOATING
C994 VIN.n8 VSS 0.02533f ; **FLOATING
C995 VIN.n9 VSS 0.02533f ; **FLOATING
C996 VIN.n10 VSS 0.02533f ; **FLOATING
C997 VIN.n11 VSS 0.02533f ; **FLOATING
C998 VIN.n12 VSS 0.02533f ; **FLOATING
C999 VIN.n13 VSS 0.02533f ; **FLOATING
C1000 VIN.n14 VSS 0.02533f ; **FLOATING
C1001 VIN.n15 VSS 0.02533f ; **FLOATING
C1002 VIN.n16 VSS 0.02533f ; **FLOATING
C1003 VIN.n17 VSS 0.02533f ; **FLOATING
C1004 VIN.n18 VSS 0.02533f ; **FLOATING
C1005 VIN.n19 VSS 0.02533f ; **FLOATING
C1006 VIN.n20 VSS 0.02533f ; **FLOATING
C1007 VIN.n21 VSS 0.02533f ; **FLOATING
C1008 VIN.n22 VSS 0.02533f ; **FLOATING
C1009 VIN.n23 VSS 0.02533f ; **FLOATING
C1010 VIN.n24 VSS 0.02533f ; **FLOATING
C1011 VIN.n25 VSS 0.02533f ; **FLOATING
C1012 VIN.n26 VSS 0.02533f ; **FLOATING
C1013 VIN.n27 VSS 0.02533f ; **FLOATING
C1014 VIN.n28 VSS 0.02533f ; **FLOATING
C1015 VIN.n29 VSS 0.02533f ; **FLOATING
C1016 VIN.n30 VSS 0.02533f ; **FLOATING
C1017 VIN.n31 VSS 0.02533f ; **FLOATING
C1018 VIN.n32 VSS 0.02533f ; **FLOATING
C1019 VIN.n33 VSS 0.02533f ; **FLOATING
C1020 VIN.n34 VSS 0.02533f ; **FLOATING
C1021 VIN.n35 VSS 0.02533f ; **FLOATING
C1022 VIN.n36 VSS 0.02533f ; **FLOATING
C1023 VIN.n37 VSS 0.02533f ; **FLOATING
C1024 VIN.n38 VSS 0.02533f ; **FLOATING
C1025 VIN.n39 VSS 0.02533f ; **FLOATING
C1026 VIN.n40 VSS 0.02533f ; **FLOATING
C1027 VIN.n41 VSS 0.02533f ; **FLOATING
C1028 VIN.n42 VSS 0.02533f ; **FLOATING
C1029 VIN.n43 VSS 0.02533f ; **FLOATING
C1030 VIN.n44 VSS 0.02533f ; **FLOATING
C1031 VIN.n45 VSS 0.02533f ; **FLOATING
C1032 VIN.n46 VSS 0.02533f ; **FLOATING
C1033 VIN.n47 VSS 0.02533f ; **FLOATING
C1034 VIN.n48 VSS 0.02533f ; **FLOATING
C1035 VIN.n49 VSS 0.02533f ; **FLOATING
C1036 VIN.n50 VSS 0.02533f ; **FLOATING
C1037 VIN.n51 VSS 0.02533f ; **FLOATING
C1038 VIN.n52 VSS 0.02533f ; **FLOATING
C1039 VIN.n53 VSS 0.02533f ; **FLOATING
C1040 VIN.n54 VSS 0.02533f ; **FLOATING
C1041 VIN.n55 VSS 0.02533f ; **FLOATING
C1042 VIN.n56 VSS 0.02533f ; **FLOATING
C1043 VIN.n57 VSS 0.02533f ; **FLOATING
C1044 VIN.n58 VSS 0.02533f ; **FLOATING
C1045 VIN.n59 VSS 0.02533f ; **FLOATING
C1046 VIN.n60 VSS 0.02533f ; **FLOATING
C1047 VIN.n61 VSS 0.02533f ; **FLOATING
C1048 VIN.n62 VSS 0.02533f ; **FLOATING
C1049 VIN.n63 VSS 0.02533f ; **FLOATING
C1050 VIN.n64 VSS 0.02533f ; **FLOATING
C1051 VIN.n65 VSS 0.02533f ; **FLOATING
C1052 VIN.n66 VSS 0.02533f ; **FLOATING
C1053 VIN.n67 VSS 0.02533f ; **FLOATING
C1054 VIN.n68 VSS 0.02533f ; **FLOATING
C1055 VIN.n69 VSS 0.02533f ; **FLOATING
C1056 VIN.n70 VSS 0.02533f ; **FLOATING
C1057 VIN.n71 VSS 0.02533f ; **FLOATING
C1058 VIN.n72 VSS 0.02533f ; **FLOATING
C1059 VIN.n73 VSS 0.02533f ; **FLOATING
C1060 VIN.n74 VSS 0.02533f ; **FLOATING
C1061 VIN.n75 VSS 0.02533f ; **FLOATING
C1062 VIN.n76 VSS 0.02533f ; **FLOATING
C1063 VIN.n77 VSS 0.02533f ; **FLOATING
C1064 VIN.n78 VSS 0.02533f ; **FLOATING
C1065 VIN.n79 VSS 0.02533f ; **FLOATING
C1066 VIN.n80 VSS 0.02533f ; **FLOATING
C1067 VIN.n81 VSS 0.02533f ; **FLOATING
C1068 VIN.n82 VSS 0.02533f ; **FLOATING
C1069 VIN.n83 VSS 0.02533f ; **FLOATING
C1070 VIN.n84 VSS 0.02533f ; **FLOATING
C1071 VIN.n85 VSS 0.02533f ; **FLOATING
C1072 VIN.n86 VSS 0.02533f ; **FLOATING
C1073 VIN.n87 VSS 0.02533f ; **FLOATING
C1074 VIN.n88 VSS 0.02533f ; **FLOATING
C1075 VIN.n89 VSS 0.02533f ; **FLOATING
C1076 VIN.n90 VSS 0.02533f ; **FLOATING
C1077 VIN.n91 VSS 0.02533f ; **FLOATING
C1078 VIN.n92 VSS 0.02533f ; **FLOATING
C1079 VIN.n94 VSS 3.59378f ; **FLOATING
C1080 VIN.n95 VSS 0.9888f ; **FLOATING
C1081 VIN.n96 VSS 0.02058f ; **FLOATING
C1082 VIN.n97 VSS 0.2168f ; **FLOATING
C1083 VIN.n98 VSS 0.02533f ; **FLOATING
C1084 VIN.n99 VSS 0.02533f ; **FLOATING
C1085 VIN.n100 VSS 0.02533f ; **FLOATING
C1086 VIN.n101 VSS 0.02533f ; **FLOATING
C1087 VIN.n102 VSS 0.02533f ; **FLOATING
C1088 VIN.n103 VSS 0.02533f ; **FLOATING
C1089 VIN.n104 VSS 0.02533f ; **FLOATING
C1090 VIN.n105 VSS 0.02533f ; **FLOATING
C1091 VIN.n106 VSS 0.02533f ; **FLOATING
C1092 VIN.n107 VSS 0.02533f ; **FLOATING
C1093 VIN.n108 VSS 0.02533f ; **FLOATING
C1094 VIN.n109 VSS 0.02533f ; **FLOATING
C1095 VIN.n110 VSS 0.02533f ; **FLOATING
C1096 VIN.n111 VSS 0.02533f ; **FLOATING
C1097 VIN.n112 VSS 0.02533f ; **FLOATING
C1098 VIN.n113 VSS 0.02533f ; **FLOATING
C1099 VIN.n114 VSS 0.02533f ; **FLOATING
C1100 VIN.n115 VSS 0.02533f ; **FLOATING
C1101 VIN.n116 VSS 0.02533f ; **FLOATING
C1102 VIN.n117 VSS 0.02533f ; **FLOATING
C1103 VIN.n118 VSS 0.02533f ; **FLOATING
C1104 VIN.n119 VSS 0.02533f ; **FLOATING
C1105 VIN.n120 VSS 0.02533f ; **FLOATING
C1106 VIN.n121 VSS 0.02533f ; **FLOATING
C1107 VIN.n122 VSS 0.02533f ; **FLOATING
C1108 VIN.n123 VSS 0.02533f ; **FLOATING
C1109 VIN.n124 VSS 0.02533f ; **FLOATING
C1110 VIN.n125 VSS 0.02533f ; **FLOATING
C1111 VIN.n126 VSS 0.02533f ; **FLOATING
C1112 VIN.n127 VSS 0.02533f ; **FLOATING
C1113 VIN.n128 VSS 0.02533f ; **FLOATING
C1114 VIN.n129 VSS 0.02533f ; **FLOATING
C1115 VIN.n130 VSS 0.02533f ; **FLOATING
C1116 VIN.n131 VSS 0.02533f ; **FLOATING
C1117 VIN.n132 VSS 0.02533f ; **FLOATING
C1118 VIN.n133 VSS 0.02533f ; **FLOATING
C1119 VIN.n134 VSS 0.02533f ; **FLOATING
C1120 VIN.n135 VSS 0.02533f ; **FLOATING
C1121 VIN.n136 VSS 0.02533f ; **FLOATING
C1122 VIN.n137 VSS 0.02533f ; **FLOATING
C1123 VIN.n138 VSS 0.02533f ; **FLOATING
C1124 VIN.n139 VSS 0.02533f ; **FLOATING
C1125 VIN.n140 VSS 0.02533f ; **FLOATING
C1126 VIN.n141 VSS 0.02533f ; **FLOATING
C1127 VIN.n142 VSS 0.02533f ; **FLOATING
C1128 VIN.n143 VSS 0.02533f ; **FLOATING
C1129 VIN.n144 VSS 0.02533f ; **FLOATING
C1130 VIN.n145 VSS 0.02533f ; **FLOATING
C1131 VIN.n146 VSS 0.02533f ; **FLOATING
C1132 VIN.n147 VSS 0.02533f ; **FLOATING
C1133 VIN.n148 VSS 0.02533f ; **FLOATING
C1134 VIN.n149 VSS 0.02533f ; **FLOATING
C1135 VIN.n150 VSS 0.02533f ; **FLOATING
C1136 VIN.n151 VSS 0.02533f ; **FLOATING
C1137 VIN.n152 VSS 0.02533f ; **FLOATING
C1138 VIN.n153 VSS 0.02533f ; **FLOATING
C1139 VIN.n154 VSS 0.02533f ; **FLOATING
C1140 VIN.n155 VSS 0.02533f ; **FLOATING
C1141 VIN.n156 VSS 0.02533f ; **FLOATING
C1142 VIN.n157 VSS 0.02533f ; **FLOATING
C1143 VIN.n158 VSS 0.02533f ; **FLOATING
C1144 VIN.n159 VSS 0.02533f ; **FLOATING
C1145 VIN.n160 VSS 0.02533f ; **FLOATING
C1146 VIN.n161 VSS 0.02533f ; **FLOATING
C1147 VIN.n162 VSS 0.02533f ; **FLOATING
C1148 VIN.n163 VSS 0.02533f ; **FLOATING
C1149 VIN.n164 VSS 0.02533f ; **FLOATING
C1150 VIN.n165 VSS 0.02533f ; **FLOATING
C1151 VIN.n166 VSS 0.02533f ; **FLOATING
C1152 VIN.n167 VSS 0.02533f ; **FLOATING
C1153 VIN.n168 VSS 0.02533f ; **FLOATING
C1154 VIN.n169 VSS 0.02533f ; **FLOATING
C1155 VIN.n170 VSS 0.02533f ; **FLOATING
C1156 VIN.n171 VSS 0.02533f ; **FLOATING
C1157 VIN.n172 VSS 0.02533f ; **FLOATING
C1158 VIN.n173 VSS 0.02533f ; **FLOATING
C1159 VIN.n174 VSS 0.02533f ; **FLOATING
C1160 VIN.n175 VSS 0.02533f ; **FLOATING
C1161 VIN.n176 VSS 0.02533f ; **FLOATING
C1162 VIN.n177 VSS 0.02533f ; **FLOATING
C1163 VIN.n178 VSS 0.02533f ; **FLOATING
C1164 VIN.n179 VSS 0.02533f ; **FLOATING
C1165 VIN.n180 VSS 0.02533f ; **FLOATING
C1166 VIN.n181 VSS 0.02533f ; **FLOATING
C1167 VIN.n182 VSS 0.02533f ; **FLOATING
C1168 VIN.n183 VSS 0.02533f ; **FLOATING
C1169 VIN.n184 VSS 0.2168f ; **FLOATING
C1170 VIN.n186 VSS 0.27748f ; **FLOATING
C1171 VIN.n187 VSS 0.01824f ; **FLOATING
C1172 VIN.n188 VSS 0.01824f ; **FLOATING
C1173 VIN.n189 VSS 0.01824f ; **FLOATING
C1174 VIN.n190 VSS 0.01824f ; **FLOATING
C1175 VIN.n191 VSS 0.01824f ; **FLOATING
C1176 VIN.n192 VSS 0.01824f ; **FLOATING
C1177 VIN.n193 VSS 0.01824f ; **FLOATING
C1178 VIN.n194 VSS 0.01824f ; **FLOATING
C1179 VIN.n195 VSS 0.01824f ; **FLOATING
C1180 VIN.n196 VSS 0.01824f ; **FLOATING
C1181 VIN.n197 VSS 0.01824f ; **FLOATING
C1182 VIN.n198 VSS 0.01824f ; **FLOATING
C1183 VIN.n199 VSS 0.01824f ; **FLOATING
C1184 VIN.n200 VSS 0.01824f ; **FLOATING
C1185 VIN.n201 VSS 0.01824f ; **FLOATING
C1186 VIN.n202 VSS 0.01824f ; **FLOATING
C1187 VIN.n203 VSS 0.01824f ; **FLOATING
C1188 VIN.n204 VSS 0.01824f ; **FLOATING
C1189 VIN.n205 VSS 0.01824f ; **FLOATING
C1190 VIN.n206 VSS 0.01824f ; **FLOATING
C1191 VIN.n207 VSS 0.01824f ; **FLOATING
C1192 VIN.n208 VSS 0.01824f ; **FLOATING
C1193 VIN.n209 VSS 0.01824f ; **FLOATING
C1194 VIN.n210 VSS 0.01824f ; **FLOATING
C1195 VIN.n211 VSS 0.01824f ; **FLOATING
C1196 VIN.n212 VSS 0.01824f ; **FLOATING
C1197 VIN.n213 VSS 0.01824f ; **FLOATING
C1198 VIN.n214 VSS 0.01824f ; **FLOATING
C1199 VIN.n215 VSS 0.01824f ; **FLOATING
C1200 VIN.n216 VSS 0.01824f ; **FLOATING
C1201 VIN.n217 VSS 0.01824f ; **FLOATING
C1202 VIN.n218 VSS 0.01824f ; **FLOATING
C1203 VIN.n219 VSS 0.01824f ; **FLOATING
C1204 VIN.n220 VSS 0.01824f ; **FLOATING
C1205 VIN.n221 VSS 0.01824f ; **FLOATING
C1206 VIN.n222 VSS 0.01824f ; **FLOATING
C1207 VIN.n223 VSS 0.01824f ; **FLOATING
C1208 VIN.n224 VSS 0.01824f ; **FLOATING
C1209 VIN.n225 VSS 0.01824f ; **FLOATING
C1210 VIN.n226 VSS 0.01824f ; **FLOATING
C1211 VIN.n227 VSS 0.01824f ; **FLOATING
C1212 VIN.n228 VSS 0.01824f ; **FLOATING
C1213 VIN.n229 VSS 0.01824f ; **FLOATING
C1214 VIN.n230 VSS 0.27748f ; **FLOATING
C1215 VIN.n231 VSS 0.02058f ; **FLOATING
C1216 VIN.n232 VSS 2.90818f ; **FLOATING
C1217 VIN.n233 VSS 0.27748f ; **FLOATING
C1218 VIN.n234 VSS 2.29164f ; **FLOATING
C1219 VIN.n235 VSS 0.01824f ; **FLOATING
C1220 VIN.n236 VSS 2.03383f ; **FLOATING
C1221 VIN.n237 VSS 0.01824f ; **FLOATING
C1222 VIN.n238 VSS 1.40363f ; **FLOATING
C1223 VIN.n239 VSS 0.01824f ; **FLOATING
C1224 VIN.n240 VSS 1.33201f ; **FLOATING
C1225 VIN.n241 VSS 0.01824f ; **FLOATING
C1226 VIN.n242 VSS 1.58982f ; **FLOATING
C1227 VIN.n243 VSS 0.01824f ; **FLOATING
C1228 VIN.n244 VSS 1.58982f ; **FLOATING
C1229 VIN.n245 VSS 0.01824f ; **FLOATING
C1230 VIN.n246 VSS 1.21743f ; **FLOATING
C1231 VIN.n247 VSS 0.01824f ; **FLOATING
C1232 VIN.n248 VSS 1.51821f ; **FLOATING
C1233 VIN.n249 VSS 0.01824f ; **FLOATING
C1234 VIN.n250 VSS 1.58982f ; **FLOATING
C1235 VIN.n251 VSS 0.01824f ; **FLOATING
C1236 VIN.n252 VSS 1.47524f ; **FLOATING
C1237 VIN.n253 VSS 0.01824f ; **FLOATING
C1238 VIN.n254 VSS 1.2604f ; **FLOATING
C1239 VIN.n255 VSS 0.01824f ; **FLOATING
C1240 VIN.n256 VSS 1.58982f ; **FLOATING
C1241 VIN.n257 VSS 0.01824f ; **FLOATING
C1242 VIN.n258 VSS 1.58982f ; **FLOATING
C1243 VIN.n259 VSS 0.01824f ; **FLOATING
C1244 VIN.n260 VSS 1.28905f ; **FLOATING
C1245 VIN.n261 VSS 0.01824f ; **FLOATING
C1246 VIN.n262 VSS 1.4466f ; **FLOATING
C1247 VIN.n263 VSS 0.01824f ; **FLOATING
C1248 VIN.n264 VSS 1.58982f ; **FLOATING
C1249 VIN.n265 VSS 0.01824f ; **FLOATING
C1250 VIN.n266 VSS 1.54685f ; **FLOATING
C1251 VIN.n267 VSS 0.01824f ; **FLOATING
C1252 VIN.n268 VSS 1.18879f ; **FLOATING
C1253 VIN.n269 VSS 0.01824f ; **FLOATING
C1254 VIN.n270 VSS 1.58982f ; **FLOATING
C1255 VIN.n271 VSS 0.01824f ; **FLOATING
C1256 VIN.n272 VSS 1.58982f ; **FLOATING
C1257 VIN.n273 VSS 0.01824f ; **FLOATING
C1258 VIN.n274 VSS 1.36066f ; **FLOATING
C1259 VIN.n275 VSS 0.01824f ; **FLOATING
C1260 VIN.n276 VSS 1.37498f ; **FLOATING
C1261 VIN.n277 VSS 0.01824f ; **FLOATING
C1262 VIN.n278 VSS 1.58982f ; **FLOATING
C1263 VIN.n279 VSS 0.01824f ; **FLOATING
C1264 VIN.n280 VSS 1.58982f ; **FLOATING
C1265 VIN.n281 VSS 0.01824f ; **FLOATING
C1266 VIN.n282 VSS 1.17446f ; **FLOATING
C1267 VIN.n283 VSS 0.01824f ; **FLOATING
C1268 VIN.n284 VSS 1.56118f ; **FLOATING
C1269 VIN.n285 VSS 0.01824f ; **FLOATING
C1270 VIN.n286 VSS 1.58982f ; **FLOATING
C1271 VIN.n287 VSS 0.01824f ; **FLOATING
C1272 VIN.n288 VSS 1.43227f ; **FLOATING
C1273 VIN.n289 VSS 0.01824f ; **FLOATING
C1274 VIN.n290 VSS 1.30337f ; **FLOATING
C1275 VIN.n291 VSS 0.01824f ; **FLOATING
C1276 VIN.n292 VSS 1.58982f ; **FLOATING
C1277 VIN.n293 VSS 0.01824f ; **FLOATING
C1278 VIN.n294 VSS 1.58982f ; **FLOATING
C1279 VIN.n295 VSS 0.01824f ; **FLOATING
C1280 VIN.n296 VSS 1.24608f ; **FLOATING
C1281 VIN.n297 VSS 0.01824f ; **FLOATING
C1282 VIN.n298 VSS 1.48956f ; **FLOATING
C1283 VIN.n299 VSS 0.01824f ; **FLOATING
C1284 VIN.n300 VSS 1.58982f ; **FLOATING
C1285 VIN.n301 VSS 0.01824f ; **FLOATING
C1286 VIN.n302 VSS 1.50389f ; **FLOATING
C1287 VIN.n303 VSS 0.01824f ; **FLOATING
C1288 VIN.n304 VSS 1.23175f ; **FLOATING
C1289 VIN.n305 VSS 0.01824f ; **FLOATING
C1290 VIN.n306 VSS 1.58982f ; **FLOATING
C1291 VIN.n307 VSS 0.01824f ; **FLOATING
C1292 VIN.n308 VSS 1.58982f ; **FLOATING
C1293 VIN.n309 VSS 0.01824f ; **FLOATING
C1294 VIN.n310 VSS 1.31769f ; **FLOATING
C1295 VIN.n311 VSS 0.01824f ; **FLOATING
C1296 VIN.n312 VSS 1.41795f ; **FLOATING
C1297 VIN.n313 VSS 0.01824f ; **FLOATING
C1298 VIN.n314 VSS 1.58982f ; **FLOATING
C1299 VIN.n315 VSS 0.01824f ; **FLOATING
C1300 VIN.n316 VSS 1.5755f ; **FLOATING
C1301 VIN.n317 VSS 0.01824f ; **FLOATING
C1302 VIN.n318 VSS 1.16014f ; **FLOATING
C1303 VIN.n319 VSS 0.01824f ; **FLOATING
C1304 VIN.n320 VSS 2.89386f ; **FLOATING
C1305 VIN.t16 VSS 1.14582f ; **FLOATING
C1306 VIN.t48 VSS 1.14582f ; **FLOATING
C1307 VIN.t8 VSS 1.14582f ; **FLOATING
C1308 VIN.t65 VSS 1.14582f ; **FLOATING
C1309 VIN.t22 VSS 1.14582f ; **FLOATING
C1310 VIN.t34 VSS 1.14582f ; **FLOATING
C1311 VIN.t6 VSS 1.14582f ; **FLOATING
C1312 VIN.t36 VSS 1.14582f ; **FLOATING
C1313 VIN.t11 VSS 1.14582f ; **FLOATING
C1314 VIN.t57 VSS 1.14582f ; **FLOATING
C1315 VIN.t46 VSS 1.14582f ; **FLOATING
C1316 VIN.t62 VSS 1.14582f ; **FLOATING
C1317 VIN.t41 VSS 1.14582f ; **FLOATING
C1318 VIN.t26 VSS 1.14582f ; **FLOATING
C1319 VIN.t132 VSS 1.14582f ; **FLOATING
C1320 VIN.t30 VSS 1.14582f ; **FLOATING
C1321 VIN.t18 VSS 1.14582f ; **FLOATING
C1322 VIN.t2 VSS 1.14582f ; **FLOATING
C1323 VIN.t142 VSS 1.14582f ; **FLOATING
C1324 VIN.t144 VSS 1.14582f ; **FLOATING
C1325 VIN.t68 VSS 1.14582f ; **FLOATING
C1326 VIN.t28 VSS 1.14582f ; **FLOATING
C1327 VIN.t39 VSS 1.14582f ; **FLOATING
C1328 VIN.t13 VSS 1.14582f ; **FLOATING
C1329 VIN.t0 VSS 1.14582f ; **FLOATING
C1330 VIN.t20 VSS 1.14582f ; **FLOATING
C1331 VIN.t4 VSS 1.14582f ; **FLOATING
C1332 VIN.t51 VSS 1.14582f ; **FLOATING
C1333 VIN.t53 VSS 1.14582f ; **FLOATING
C1334 VIN.t43 VSS 1.14582f ; **FLOATING
C1335 VIN.n321 VSS 0.27748f ; **FLOATING
C1336 VIN.n322 VSS 0.02058f ; **FLOATING
C1337 VIN.n323 VSS 3.59378f ; **FLOATING
C1338 VIN.n324 VSS 0.99188f ; **FLOATING
C1339 VIN.n325 VSS 0.40841f ; **FLOATING
C1340 VIN.n326 VSS 1.39379f ; **FLOATING
C1341 VIN.t25 VSS 0.55541f ; **FLOATING
C1342 VIN.t275 VSS 0.52901f ; **FLOATING
C1343 VIN.n327 VSS 0.63857f ; **FLOATING
C1344 VIN.n328 VSS 0.85408f ; **FLOATING
C1345 VIN.t250 VSS 0.52108f ; **FLOATING
C1346 VIN.n329 VSS 0.72634f ; **FLOATING
C1347 VIN.t174 VSS 0.65786f ; **FLOATING
C1348 VIN.n330 VSS 1.81148f ; **FLOATING
C1349 VIN.n331 VSS 3.6419f ; **FLOATING
C1350 VIN.n332 VSS 0.02058f ; **FLOATING
C1351 VIN.n333 VSS 0.02929f ; **FLOATING
C1352 VIN.n334 VSS 0.06941f ; **FLOATING
C1353 VIN.n335 VSS 0.02533f ; **FLOATING
C1354 VIN.n336 VSS 0.02533f ; **FLOATING
C1355 VIN.n337 VSS 0.02533f ; **FLOATING
C1356 VIN.n338 VSS 0.02533f ; **FLOATING
C1357 VIN.n339 VSS 0.02533f ; **FLOATING
C1358 VIN.n340 VSS 0.02533f ; **FLOATING
C1359 VIN.n341 VSS 0.02533f ; **FLOATING
C1360 VIN.n342 VSS 0.02533f ; **FLOATING
C1361 VIN.n343 VSS 0.02533f ; **FLOATING
C1362 VIN.n344 VSS 0.02533f ; **FLOATING
C1363 VIN.n345 VSS 0.02533f ; **FLOATING
C1364 VIN.n346 VSS 0.02533f ; **FLOATING
C1365 VIN.n347 VSS 0.02533f ; **FLOATING
C1366 VIN.n348 VSS 0.02533f ; **FLOATING
C1367 VIN.n349 VSS 0.02533f ; **FLOATING
C1368 VIN.n350 VSS 0.02533f ; **FLOATING
C1369 VIN.n351 VSS 0.02533f ; **FLOATING
C1370 VIN.n352 VSS 0.02533f ; **FLOATING
C1371 VIN.n353 VSS 0.02533f ; **FLOATING
C1372 VIN.n354 VSS 0.02533f ; **FLOATING
C1373 VIN.n355 VSS 0.02533f ; **FLOATING
C1374 VIN.n356 VSS 0.02533f ; **FLOATING
C1375 VIN.n357 VSS 0.02533f ; **FLOATING
C1376 VIN.n358 VSS 0.02533f ; **FLOATING
C1377 VIN.n359 VSS 0.02533f ; **FLOATING
C1378 VIN.n360 VSS 0.02533f ; **FLOATING
C1379 VIN.n361 VSS 0.02533f ; **FLOATING
C1380 VIN.n362 VSS 0.02533f ; **FLOATING
C1381 VIN.n363 VSS 0.02533f ; **FLOATING
C1382 VIN.n364 VSS 0.02533f ; **FLOATING
C1383 VIN.n365 VSS 0.02533f ; **FLOATING
C1384 VIN.n366 VSS 0.02533f ; **FLOATING
C1385 VIN.n367 VSS 0.02533f ; **FLOATING
C1386 VIN.n368 VSS 0.02533f ; **FLOATING
C1387 VIN.n369 VSS 0.02533f ; **FLOATING
C1388 VIN.n370 VSS 0.02533f ; **FLOATING
C1389 VIN.n371 VSS 0.02533f ; **FLOATING
C1390 VIN.n372 VSS 0.02533f ; **FLOATING
C1391 VIN.n373 VSS 0.02533f ; **FLOATING
C1392 VIN.n374 VSS 0.02533f ; **FLOATING
C1393 VIN.n375 VSS 0.02533f ; **FLOATING
C1394 VIN.n376 VSS 0.02533f ; **FLOATING
C1395 VIN.n377 VSS 0.02533f ; **FLOATING
C1396 VIN.n378 VSS 0.02533f ; **FLOATING
C1397 VIN.n379 VSS 0.02533f ; **FLOATING
C1398 VIN.n380 VSS 0.02533f ; **FLOATING
C1399 VIN.n381 VSS 0.02533f ; **FLOATING
C1400 VIN.n382 VSS 0.02533f ; **FLOATING
C1401 VIN.n383 VSS 0.02533f ; **FLOATING
C1402 VIN.n384 VSS 0.02533f ; **FLOATING
C1403 VIN.n385 VSS 0.02533f ; **FLOATING
C1404 VIN.n386 VSS 0.02533f ; **FLOATING
C1405 VIN.n387 VSS 0.02533f ; **FLOATING
C1406 VIN.n388 VSS 0.02533f ; **FLOATING
C1407 VIN.n389 VSS 0.02533f ; **FLOATING
C1408 VIN.n390 VSS 0.02533f ; **FLOATING
C1409 VIN.n391 VSS 0.02533f ; **FLOATING
C1410 VIN.n392 VSS 0.02533f ; **FLOATING
C1411 VIN.n393 VSS 0.02533f ; **FLOATING
C1412 VIN.n394 VSS 0.02533f ; **FLOATING
C1413 VIN.n395 VSS 0.02533f ; **FLOATING
C1414 VIN.n396 VSS 0.02533f ; **FLOATING
C1415 VIN.n397 VSS 0.02533f ; **FLOATING
C1416 VIN.n398 VSS 0.02533f ; **FLOATING
C1417 VIN.n399 VSS 0.02533f ; **FLOATING
C1418 VIN.n400 VSS 0.02533f ; **FLOATING
C1419 VIN.n401 VSS 0.02533f ; **FLOATING
C1420 VIN.n402 VSS 0.02533f ; **FLOATING
C1421 VIN.n403 VSS 0.02533f ; **FLOATING
C1422 VIN.n404 VSS 0.02533f ; **FLOATING
C1423 VIN.n405 VSS 0.02533f ; **FLOATING
C1424 VIN.n406 VSS 0.02533f ; **FLOATING
C1425 VIN.n407 VSS 0.02533f ; **FLOATING
C1426 VIN.n408 VSS 0.02533f ; **FLOATING
C1427 VIN.n409 VSS 0.02533f ; **FLOATING
C1428 VIN.n410 VSS 0.02533f ; **FLOATING
C1429 VIN.n411 VSS 0.02533f ; **FLOATING
C1430 VIN.n412 VSS 0.02533f ; **FLOATING
C1431 VIN.n413 VSS 0.02533f ; **FLOATING
C1432 VIN.n414 VSS 0.02533f ; **FLOATING
C1433 VIN.n415 VSS 0.02533f ; **FLOATING
C1434 VIN.n416 VSS 0.02533f ; **FLOATING
C1435 VIN.n417 VSS 0.02533f ; **FLOATING
C1436 VIN.n418 VSS 0.02533f ; **FLOATING
C1437 VIN.n419 VSS 0.02533f ; **FLOATING
C1438 VIN.n420 VSS 0.02533f ; **FLOATING
C1439 VIN.n421 VSS 0.02533f ; **FLOATING
C1440 VIN.n422 VSS 0.02533f ; **FLOATING
C1441 VIN.n423 VSS 0.02533f ; **FLOATING
C1442 VIN.n424 VSS 0.02533f ; **FLOATING
C1443 VIN.n425 VSS 0.02533f ; **FLOATING
C1444 VIN.n426 VSS 0.02533f ; **FLOATING
C1445 VIN.n427 VSS 0.02533f ; **FLOATING
C1446 VIN.n428 VSS 0.02533f ; **FLOATING
C1447 VIN.n429 VSS 0.02533f ; **FLOATING
C1448 VIN.n430 VSS 0.02533f ; **FLOATING
C1449 VIN.n431 VSS 0.02533f ; **FLOATING
C1450 VIN.n432 VSS 0.02533f ; **FLOATING
C1451 VIN.n434 VSS 0.55173f ; **FLOATING
C1452 VIN.n435 VSS 0.16069f ; **FLOATING
C1453 VIN.n436 VSS 0.02058f ; **FLOATING
C1454 VIN.n437 VSS 0.06941f ; **FLOATING
C1455 VIN.n438 VSS 0.06941f ; **FLOATING
C1456 VIN.n439 VSS 0.02533f ; **FLOATING
C1457 VIN.n440 VSS 0.02533f ; **FLOATING
C1458 VIN.n441 VSS 0.02533f ; **FLOATING
C1459 VIN.n442 VSS 0.02533f ; **FLOATING
C1460 VIN.n443 VSS 0.02533f ; **FLOATING
C1461 VIN.n444 VSS 0.02533f ; **FLOATING
C1462 VIN.n445 VSS 0.02533f ; **FLOATING
C1463 VIN.n446 VSS 0.02533f ; **FLOATING
C1464 VIN.n447 VSS 0.02533f ; **FLOATING
C1465 VIN.n448 VSS 0.02533f ; **FLOATING
C1466 VIN.n449 VSS 0.02533f ; **FLOATING
C1467 VIN.n450 VSS 0.02533f ; **FLOATING
C1468 VIN.n451 VSS 0.02533f ; **FLOATING
C1469 VIN.n452 VSS 0.02533f ; **FLOATING
C1470 VIN.n453 VSS 0.02533f ; **FLOATING
C1471 VIN.n454 VSS 0.02533f ; **FLOATING
C1472 VIN.n455 VSS 0.02533f ; **FLOATING
C1473 VIN.n456 VSS 0.02533f ; **FLOATING
C1474 VIN.n457 VSS 0.02533f ; **FLOATING
C1475 VIN.n458 VSS 0.02533f ; **FLOATING
C1476 VIN.n459 VSS 0.02533f ; **FLOATING
C1477 VIN.n460 VSS 0.02533f ; **FLOATING
C1478 VIN.n461 VSS 0.02533f ; **FLOATING
C1479 VIN.n462 VSS 0.02533f ; **FLOATING
C1480 VIN.n463 VSS 0.02533f ; **FLOATING
C1481 VIN.n464 VSS 0.02533f ; **FLOATING
C1482 VIN.n465 VSS 0.02533f ; **FLOATING
C1483 VIN.n466 VSS 0.02533f ; **FLOATING
C1484 VIN.n467 VSS 0.02533f ; **FLOATING
C1485 VIN.n468 VSS 0.02533f ; **FLOATING
C1486 VIN.n469 VSS 0.02533f ; **FLOATING
C1487 VIN.n470 VSS 0.02533f ; **FLOATING
C1488 VIN.n471 VSS 0.02533f ; **FLOATING
C1489 VIN.n472 VSS 0.02533f ; **FLOATING
C1490 VIN.n473 VSS 0.02533f ; **FLOATING
C1491 VIN.n474 VSS 0.02533f ; **FLOATING
C1492 VIN.n475 VSS 0.02533f ; **FLOATING
C1493 VIN.n476 VSS 0.02533f ; **FLOATING
C1494 VIN.n477 VSS 0.02533f ; **FLOATING
C1495 VIN.n478 VSS 0.02533f ; **FLOATING
C1496 VIN.n479 VSS 0.02533f ; **FLOATING
C1497 VIN.n480 VSS 0.02533f ; **FLOATING
C1498 VIN.n481 VSS 0.02533f ; **FLOATING
C1499 VIN.n482 VSS 0.02533f ; **FLOATING
C1500 VIN.n483 VSS 0.02533f ; **FLOATING
C1501 VIN.n484 VSS 0.02533f ; **FLOATING
C1502 VIN.n485 VSS 0.02533f ; **FLOATING
C1503 VIN.n486 VSS 0.02533f ; **FLOATING
C1504 VIN.n487 VSS 0.02533f ; **FLOATING
C1505 VIN.n488 VSS 0.02533f ; **FLOATING
C1506 VIN.n489 VSS 0.02533f ; **FLOATING
C1507 VIN.n490 VSS 0.02533f ; **FLOATING
C1508 VIN.n491 VSS 0.02533f ; **FLOATING
C1509 VIN.n492 VSS 0.02533f ; **FLOATING
C1510 VIN.n493 VSS 0.02533f ; **FLOATING
C1511 VIN.n494 VSS 0.02533f ; **FLOATING
C1512 VIN.n495 VSS 0.02533f ; **FLOATING
C1513 VIN.n496 VSS 0.02533f ; **FLOATING
C1514 VIN.n497 VSS 0.02533f ; **FLOATING
C1515 VIN.n498 VSS 0.02533f ; **FLOATING
C1516 VIN.n499 VSS 0.02533f ; **FLOATING
C1517 VIN.n500 VSS 0.02533f ; **FLOATING
C1518 VIN.n501 VSS 0.02533f ; **FLOATING
C1519 VIN.n502 VSS 0.02533f ; **FLOATING
C1520 VIN.n503 VSS 0.02533f ; **FLOATING
C1521 VIN.n504 VSS 0.02533f ; **FLOATING
C1522 VIN.n505 VSS 0.02533f ; **FLOATING
C1523 VIN.n506 VSS 0.02533f ; **FLOATING
C1524 VIN.n507 VSS 0.02533f ; **FLOATING
C1525 VIN.n508 VSS 0.02533f ; **FLOATING
C1526 VIN.n509 VSS 0.02533f ; **FLOATING
C1527 VIN.n510 VSS 0.02533f ; **FLOATING
C1528 VIN.n511 VSS 0.02533f ; **FLOATING
C1529 VIN.n512 VSS 0.02533f ; **FLOATING
C1530 VIN.n513 VSS 0.02533f ; **FLOATING
C1531 VIN.n514 VSS 0.02533f ; **FLOATING
C1532 VIN.n515 VSS 0.02533f ; **FLOATING
C1533 VIN.n516 VSS 0.02533f ; **FLOATING
C1534 VIN.n517 VSS 0.02533f ; **FLOATING
C1535 VIN.n518 VSS 0.02533f ; **FLOATING
C1536 VIN.n519 VSS 0.02533f ; **FLOATING
C1537 VIN.n520 VSS 0.02533f ; **FLOATING
C1538 VIN.n521 VSS 0.02533f ; **FLOATING
C1539 VIN.n522 VSS 0.02533f ; **FLOATING
C1540 VIN.n523 VSS 0.02533f ; **FLOATING
C1541 VIN.n524 VSS 0.02533f ; **FLOATING
C1542 VIN.n525 VSS 0.02533f ; **FLOATING
C1543 VIN.n526 VSS 0.02533f ; **FLOATING
C1544 VIN.n527 VSS 0.02533f ; **FLOATING
C1545 VIN.n528 VSS 0.02533f ; **FLOATING
C1546 VIN.n529 VSS 0.02533f ; **FLOATING
C1547 VIN.n530 VSS 0.02533f ; **FLOATING
C1548 VIN.n531 VSS 0.02533f ; **FLOATING
C1549 VIN.n532 VSS 0.02533f ; **FLOATING
C1550 VIN.n533 VSS 0.02533f ; **FLOATING
C1551 VIN.n534 VSS 0.02533f ; **FLOATING
C1552 VIN.n535 VSS 0.02533f ; **FLOATING
C1553 VIN.n536 VSS 0.02533f ; **FLOATING
C1554 VIN.n538 VSS 0.0559f ; **FLOATING
C1555 VIN.n539 VSS 0.01824f ; **FLOATING
C1556 VIN.n540 VSS 0.01824f ; **FLOATING
C1557 VIN.n541 VSS 0.01824f ; **FLOATING
C1558 VIN.n542 VSS 0.01824f ; **FLOATING
C1559 VIN.n543 VSS 0.01824f ; **FLOATING
C1560 VIN.n544 VSS 0.01824f ; **FLOATING
C1561 VIN.n545 VSS 0.01824f ; **FLOATING
C1562 VIN.n546 VSS 0.01824f ; **FLOATING
C1563 VIN.n547 VSS 0.01824f ; **FLOATING
C1564 VIN.n548 VSS 0.01824f ; **FLOATING
C1565 VIN.n549 VSS 0.01824f ; **FLOATING
C1566 VIN.n550 VSS 0.01824f ; **FLOATING
C1567 VIN.n551 VSS 0.01824f ; **FLOATING
C1568 VIN.n552 VSS 0.01824f ; **FLOATING
C1569 VIN.n553 VSS 0.01824f ; **FLOATING
C1570 VIN.n554 VSS 0.01824f ; **FLOATING
C1571 VIN.n555 VSS 0.01824f ; **FLOATING
C1572 VIN.n556 VSS 0.01824f ; **FLOATING
C1573 VIN.n557 VSS 0.01824f ; **FLOATING
C1574 VIN.n558 VSS 0.01824f ; **FLOATING
C1575 VIN.n559 VSS 0.01824f ; **FLOATING
C1576 VIN.n560 VSS 0.01824f ; **FLOATING
C1577 VIN.n561 VSS 0.01824f ; **FLOATING
C1578 VIN.n562 VSS 0.01824f ; **FLOATING
C1579 VIN.n563 VSS 0.01824f ; **FLOATING
C1580 VIN.n564 VSS 0.01824f ; **FLOATING
C1581 VIN.n565 VSS 0.01824f ; **FLOATING
C1582 VIN.n566 VSS 0.01824f ; **FLOATING
C1583 VIN.n567 VSS 0.01824f ; **FLOATING
C1584 VIN.n568 VSS 0.01824f ; **FLOATING
C1585 VIN.n569 VSS 0.01824f ; **FLOATING
C1586 VIN.n570 VSS 0.01824f ; **FLOATING
C1587 VIN.n571 VSS 0.01824f ; **FLOATING
C1588 VIN.n572 VSS 0.01824f ; **FLOATING
C1589 VIN.n573 VSS 0.01824f ; **FLOATING
C1590 VIN.n574 VSS 0.01824f ; **FLOATING
C1591 VIN.n575 VSS 0.01824f ; **FLOATING
C1592 VIN.n576 VSS 0.01824f ; **FLOATING
C1593 VIN.n577 VSS 0.01824f ; **FLOATING
C1594 VIN.n578 VSS 0.01824f ; **FLOATING
C1595 VIN.n579 VSS 0.01824f ; **FLOATING
C1596 VIN.n580 VSS 0.01824f ; **FLOATING
C1597 VIN.n581 VSS 0.01824f ; **FLOATING
C1598 VIN.n582 VSS 0.01824f ; **FLOATING
C1599 VIN.n583 VSS 0.01824f ; **FLOATING
C1600 VIN.n584 VSS 0.01824f ; **FLOATING
C1601 VIN.n585 VSS 0.01824f ; **FLOATING
C1602 VIN.n586 VSS 0.01824f ; **FLOATING
C1603 VIN.n587 VSS 0.01824f ; **FLOATING
C1604 VIN.n588 VSS 0.0559f ; **FLOATING
C1605 VIN.n589 VSS 0.02058f ; **FLOATING
C1606 VIN.n590 VSS 0.43999f ; **FLOATING
C1607 VIN.n591 VSS 0.0559f ; **FLOATING
C1608 VIN.n592 VSS 0.30906f ; **FLOATING
C1609 VIN.n593 VSS 0.01824f ; **FLOATING
C1610 VIN.n594 VSS 0.30906f ; **FLOATING
C1611 VIN.n595 VSS 0.01824f ; **FLOATING
C1612 VIN.n596 VSS 0.30906f ; **FLOATING
C1613 VIN.n597 VSS 0.01824f ; **FLOATING
C1614 VIN.n598 VSS 0.30906f ; **FLOATING
C1615 VIN.n599 VSS 0.01824f ; **FLOATING
C1616 VIN.n600 VSS 0.30906f ; **FLOATING
C1617 VIN.n601 VSS 0.01824f ; **FLOATING
C1618 VIN.n602 VSS 0.30906f ; **FLOATING
C1619 VIN.n603 VSS 0.01824f ; **FLOATING
C1620 VIN.n604 VSS 0.30906f ; **FLOATING
C1621 VIN.n605 VSS 0.01824f ; **FLOATING
C1622 VIN.n606 VSS 0.30906f ; **FLOATING
C1623 VIN.n607 VSS 0.01824f ; **FLOATING
C1624 VIN.n608 VSS 0.30906f ; **FLOATING
C1625 VIN.n609 VSS 0.01824f ; **FLOATING
C1626 VIN.n610 VSS 0.30906f ; **FLOATING
C1627 VIN.n611 VSS 0.01824f ; **FLOATING
C1628 VIN.n612 VSS 0.30906f ; **FLOATING
C1629 VIN.n613 VSS 0.01824f ; **FLOATING
C1630 VIN.n614 VSS 0.30906f ; **FLOATING
C1631 VIN.n615 VSS 0.01824f ; **FLOATING
C1632 VIN.n616 VSS 0.30906f ; **FLOATING
C1633 VIN.n617 VSS 0.01824f ; **FLOATING
C1634 VIN.n618 VSS 0.30906f ; **FLOATING
C1635 VIN.n619 VSS 0.01824f ; **FLOATING
C1636 VIN.n620 VSS 0.30906f ; **FLOATING
C1637 VIN.n621 VSS 0.01824f ; **FLOATING
C1638 VIN.n622 VSS 0.30906f ; **FLOATING
C1639 VIN.n623 VSS 0.01824f ; **FLOATING
C1640 VIN.n624 VSS 0.30906f ; **FLOATING
C1641 VIN.n625 VSS 0.01824f ; **FLOATING
C1642 VIN.n626 VSS 0.30906f ; **FLOATING
C1643 VIN.n627 VSS 0.01824f ; **FLOATING
C1644 VIN.n628 VSS 0.30906f ; **FLOATING
C1645 VIN.n629 VSS 0.01824f ; **FLOATING
C1646 VIN.n630 VSS 0.30906f ; **FLOATING
C1647 VIN.n631 VSS 0.01824f ; **FLOATING
C1648 VIN.n632 VSS 0.30906f ; **FLOATING
C1649 VIN.n633 VSS 0.01824f ; **FLOATING
C1650 VIN.n634 VSS 0.30906f ; **FLOATING
C1651 VIN.n635 VSS 0.01824f ; **FLOATING
C1652 VIN.n636 VSS 0.30906f ; **FLOATING
C1653 VIN.n637 VSS 0.01824f ; **FLOATING
C1654 VIN.n638 VSS 0.30906f ; **FLOATING
C1655 VIN.n639 VSS 0.01824f ; **FLOATING
C1656 VIN.t268 VSS 0.30906f ; **FLOATING
C1657 VIN.n640 VSS 0.01824f ; **FLOATING
C1658 VIN.n641 VSS 0.30906f ; **FLOATING
C1659 VIN.n642 VSS 0.01824f ; **FLOATING
C1660 VIN.n643 VSS 0.30906f ; **FLOATING
C1661 VIN.n644 VSS 0.01824f ; **FLOATING
C1662 VIN.n645 VSS 0.30906f ; **FLOATING
C1663 VIN.n646 VSS 0.01824f ; **FLOATING
C1664 VIN.n647 VSS 0.30906f ; **FLOATING
C1665 VIN.n648 VSS 0.01824f ; **FLOATING
C1666 VIN.n649 VSS 0.30906f ; **FLOATING
C1667 VIN.n650 VSS 0.01824f ; **FLOATING
C1668 VIN.n651 VSS 0.30906f ; **FLOATING
C1669 VIN.n652 VSS 0.01824f ; **FLOATING
C1670 VIN.n653 VSS 0.30906f ; **FLOATING
C1671 VIN.n654 VSS 0.01824f ; **FLOATING
C1672 VIN.n655 VSS 0.30906f ; **FLOATING
C1673 VIN.n656 VSS 0.01824f ; **FLOATING
C1674 VIN.n657 VSS 0.30906f ; **FLOATING
C1675 VIN.n658 VSS 0.01824f ; **FLOATING
C1676 VIN.n659 VSS 0.30906f ; **FLOATING
C1677 VIN.n660 VSS 0.01824f ; **FLOATING
C1678 VIN.n661 VSS 0.30906f ; **FLOATING
C1679 VIN.n662 VSS 0.01824f ; **FLOATING
C1680 VIN.n663 VSS 0.30906f ; **FLOATING
C1681 VIN.n664 VSS 0.01824f ; **FLOATING
C1682 VIN.n665 VSS 0.30906f ; **FLOATING
C1683 VIN.n666 VSS 0.01824f ; **FLOATING
C1684 VIN.n667 VSS 0.30906f ; **FLOATING
C1685 VIN.n668 VSS 0.01824f ; **FLOATING
C1686 VIN.n669 VSS 0.30906f ; **FLOATING
C1687 VIN.n670 VSS 0.01824f ; **FLOATING
C1688 VIN.n671 VSS 0.30906f ; **FLOATING
C1689 VIN.n672 VSS 0.01824f ; **FLOATING
C1690 VIN.n673 VSS 0.30906f ; **FLOATING
C1691 VIN.n674 VSS 0.01824f ; **FLOATING
C1692 VIN.n675 VSS 0.30906f ; **FLOATING
C1693 VIN.n676 VSS 0.01824f ; **FLOATING
C1694 VIN.n677 VSS 0.30906f ; **FLOATING
C1695 VIN.n678 VSS 0.01824f ; **FLOATING
C1696 VIN.n679 VSS 0.30906f ; **FLOATING
C1697 VIN.n680 VSS 0.01824f ; **FLOATING
C1698 VIN.n681 VSS 0.30906f ; **FLOATING
C1699 VIN.n682 VSS 0.01824f ; **FLOATING
C1700 VIN.n683 VSS 0.30906f ; **FLOATING
C1701 VIN.n684 VSS 0.01824f ; **FLOATING
C1702 VIN.n685 VSS 0.30906f ; **FLOATING
C1703 VIN.n686 VSS 0.01824f ; **FLOATING
C1704 VIN.n687 VSS 0.30906f ; **FLOATING
C1705 VIN.n688 VSS 0.01824f ; **FLOATING
C1706 VIN.n689 VSS 0.43999f ; **FLOATING
C1707 VIN.n690 VSS 0.0559f ; **FLOATING
C1708 VIN.n691 VSS 0.02058f ; **FLOATING
C1709 VIN.n692 VSS 0.55173f ; **FLOATING
C1710 VIN.n693 VSS 0.16218f ; **FLOATING
C1711 VIN.n694 VSS 0.07115f ; **FLOATING
C1712 VIN.n695 VSS 0.76086f ; **FLOATING
C1713 VIN.t103 VSS 0.74007f ; **FLOATING
C1714 VIN.n696 VSS 0.96728f ; **FLOATING
C1715 VIN.t10 VSS 0.74007f ; **FLOATING
C1716 VIN.n697 VSS 1.00389f ; **FLOATING
C1717 VIN.n698 VSS 0.02058f ; **FLOATING
C1718 VIN.n699 VSS 0.02771f ; **FLOATING
C1719 VIN.n700 VSS 0.07405f ; **FLOATING
C1720 VIN.n702 VSS 0.86319f ; **FLOATING
C1721 VIN.n703 VSS 0.26137f ; **FLOATING
C1722 VIN.n704 VSS 0.02058f ; **FLOATING
C1723 VIN.n705 VSS 0.07405f ; **FLOATING
C1724 VIN.n706 VSS 0.07405f ; **FLOATING
C1725 VIN.n708 VSS 0.07808f ; **FLOATING
C1726 VIN.n709 VSS 0.07808f ; **FLOATING
C1727 VIN.n710 VSS 0.02058f ; **FLOATING
C1728 VIN.n711 VSS 0.56766f ; **FLOATING
C1729 VIN.n712 VSS 0.07808f ; **FLOATING
C1730 VIN.n713 VSS 0.56766f ; **FLOATING
C1731 VIN.t261 VSS 0.25561f ; **FLOATING
C1732 VIN.n714 VSS 0.07808f ; **FLOATING
C1733 VIN.n715 VSS 0.02058f ; **FLOATING
C1734 VIN.n716 VSS 0.86319f ; **FLOATING
C1735 VIN.n717 VSS 0.26282f ; **FLOATING
C1736 VIN.n718 VSS 0.07667f ; **FLOATING
C1737 VIN.n719 VSS 1.32594f ; **FLOATING
C1738 VIN.n720 VSS 0.02058f ; **FLOATING
C1739 VIN.n721 VSS 0.02407f ; **FLOATING
C1740 VIN.n722 VSS 0.06749f ; **FLOATING
C1741 VIN.n723 VSS 0.02533f ; **FLOATING
C1742 VIN.n724 VSS 0.02533f ; **FLOATING
C1743 VIN.n725 VSS 0.02533f ; **FLOATING
C1744 VIN.n726 VSS 0.02533f ; **FLOATING
C1745 VIN.n728 VSS 0.78747f ; **FLOATING
C1746 VIN.n729 VSS 0.26097f ; **FLOATING
C1747 VIN.n730 VSS 0.02058f ; **FLOATING
C1748 VIN.n731 VSS 0.06749f ; **FLOATING
C1749 VIN.n732 VSS 0.06749f ; **FLOATING
C1750 VIN.n733 VSS 0.02533f ; **FLOATING
C1751 VIN.n734 VSS 0.02533f ; **FLOATING
C1752 VIN.n735 VSS 0.02533f ; **FLOATING
C1753 VIN.n736 VSS 0.02533f ; **FLOATING
C1754 VIN.n738 VSS 0.0757f ; **FLOATING
C1755 VIN.n739 VSS 0.01824f ; **FLOATING
C1756 VIN.n740 VSS 0.01824f ; **FLOATING
C1757 VIN.n741 VSS 0.0757f ; **FLOATING
C1758 VIN.n742 VSS 0.02058f ; **FLOATING
C1759 VIN.n743 VSS 0.56782f ; **FLOATING
C1760 VIN.n744 VSS 0.0757f ; **FLOATING
C1761 VIN.n745 VSS 0.31312f ; **FLOATING
C1762 VIN.n746 VSS 0.01824f ; **FLOATING
C1763 VIN.n747 VSS 0.31312f ; **FLOATING
C1764 VIN.n748 VSS 0.01824f ; **FLOATING
C1765 VIN.n749 VSS 0.56782f ; **FLOATING
C1766 VIN.t263 VSS 0.25561f ; **FLOATING
C1767 VIN.t265 VSS 0.25561f ; **FLOATING
C1768 VIN.n750 VSS 0.0757f ; **FLOATING
C1769 VIN.n751 VSS 0.02058f ; **FLOATING
C1770 VIN.n752 VSS 0.78747f ; **FLOATING
C1771 VIN.n753 VSS 0.262f ; **FLOATING
C1772 VIN.n754 VSS 0.07334f ; **FLOATING
C1773 VIN.n755 VSS 1.68693f ; **FLOATING
C1774 VIN.n756 VSS 0.02058f ; **FLOATING
C1775 VIN.n757 VSS 0.02771f ; **FLOATING
C1776 VIN.n758 VSS 0.07405f ; **FLOATING
C1777 VIN.n760 VSS 0.86319f ; **FLOATING
C1778 VIN.n761 VSS 0.26137f ; **FLOATING
C1779 VIN.n762 VSS 0.02058f ; **FLOATING
C1780 VIN.n763 VSS 0.07405f ; **FLOATING
C1781 VIN.n764 VSS 0.07405f ; **FLOATING
C1782 VIN.n766 VSS 0.07808f ; **FLOATING
C1783 VIN.n767 VSS 0.07808f ; **FLOATING
C1784 VIN.n768 VSS 0.02058f ; **FLOATING
C1785 VIN.n769 VSS 0.56766f ; **FLOATING
C1786 VIN.n770 VSS 0.07808f ; **FLOATING
C1787 VIN.n771 VSS 0.56766f ; **FLOATING
C1788 VIN.t171 VSS 0.25561f ; **FLOATING
C1789 VIN.n772 VSS 0.07808f ; **FLOATING
C1790 VIN.n773 VSS 0.02058f ; **FLOATING
C1791 VIN.n774 VSS 0.86319f ; **FLOATING
C1792 VIN.n775 VSS 0.26282f ; **FLOATING
C1793 VIN.n776 VSS 0.07667f ; **FLOATING
C1794 VIN.n777 VSS 1.29427f ; **FLOATING
C1795 VIN.n778 VSS 0.02058f ; **FLOATING
C1796 VIN.n779 VSS 0.02565f ; **FLOATING
C1797 VIN.n780 VSS 0.06142f ; **FLOATING
C1798 VIN.n781 VSS 0.02533f ; **FLOATING
C1799 VIN.n782 VSS 0.02533f ; **FLOATING
C1800 VIN.n783 VSS 0.02533f ; **FLOATING
C1801 VIN.n784 VSS 0.02533f ; **FLOATING
C1802 VIN.n785 VSS 0.02533f ; **FLOATING
C1803 VIN.n786 VSS 0.02533f ; **FLOATING
C1804 VIN.n787 VSS 0.02533f ; **FLOATING
C1805 VIN.n788 VSS 0.02533f ; **FLOATING
C1806 VIN.n789 VSS 0.02533f ; **FLOATING
C1807 VIN.n790 VSS 0.02533f ; **FLOATING
C1808 VIN.n791 VSS 0.02533f ; **FLOATING
C1809 VIN.n792 VSS 0.02533f ; **FLOATING
C1810 VIN.n793 VSS 0.02533f ; **FLOATING
C1811 VIN.n794 VSS 0.02533f ; **FLOATING
C1812 VIN.n795 VSS 0.02533f ; **FLOATING
C1813 VIN.n796 VSS 0.02533f ; **FLOATING
C1814 VIN.n797 VSS 0.02533f ; **FLOATING
C1815 VIN.n798 VSS 0.02533f ; **FLOATING
C1816 VIN.n799 VSS 0.02533f ; **FLOATING
C1817 VIN.n800 VSS 0.02533f ; **FLOATING
C1818 VIN.n801 VSS 0.02533f ; **FLOATING
C1819 VIN.n802 VSS 0.02533f ; **FLOATING
C1820 VIN.n803 VSS 0.02533f ; **FLOATING
C1821 VIN.n804 VSS 0.02533f ; **FLOATING
C1822 VIN.n805 VSS 0.02533f ; **FLOATING
C1823 VIN.n806 VSS 0.02533f ; **FLOATING
C1824 VIN.n807 VSS 0.02533f ; **FLOATING
C1825 VIN.n808 VSS 0.02533f ; **FLOATING
C1826 VIN.n809 VSS 0.02533f ; **FLOATING
C1827 VIN.n810 VSS 0.02533f ; **FLOATING
C1828 VIN.n811 VSS 0.02533f ; **FLOATING
C1829 VIN.n812 VSS 0.02533f ; **FLOATING
C1830 VIN.n814 VSS 0.88193f ; **FLOATING
C1831 VIN.n815 VSS 0.17559f ; **FLOATING
C1832 VIN.n816 VSS 0.02058f ; **FLOATING
C1833 VIN.n817 VSS 0.07224f ; **FLOATING
C1834 VIN.n818 VSS 0.07224f ; **FLOATING
C1835 VIN.n819 VSS 0.02533f ; **FLOATING
C1836 VIN.n820 VSS 0.02533f ; **FLOATING
C1837 VIN.n821 VSS 0.02533f ; **FLOATING
C1838 VIN.n822 VSS 0.02533f ; **FLOATING
C1839 VIN.n823 VSS 0.02533f ; **FLOATING
C1840 VIN.n824 VSS 0.02533f ; **FLOATING
C1841 VIN.n825 VSS 0.02533f ; **FLOATING
C1842 VIN.n826 VSS 0.02533f ; **FLOATING
C1843 VIN.n827 VSS 0.02533f ; **FLOATING
C1844 VIN.n828 VSS 0.02533f ; **FLOATING
C1845 VIN.n829 VSS 0.02533f ; **FLOATING
C1846 VIN.n830 VSS 0.02533f ; **FLOATING
C1847 VIN.n831 VSS 0.02533f ; **FLOATING
C1848 VIN.n832 VSS 0.02533f ; **FLOATING
C1849 VIN.n833 VSS 0.02533f ; **FLOATING
C1850 VIN.n834 VSS 0.02533f ; **FLOATING
C1851 VIN.n835 VSS 0.02533f ; **FLOATING
C1852 VIN.n836 VSS 0.02533f ; **FLOATING
C1853 VIN.n837 VSS 0.02533f ; **FLOATING
C1854 VIN.n838 VSS 0.02533f ; **FLOATING
C1855 VIN.n839 VSS 0.02533f ; **FLOATING
C1856 VIN.n840 VSS 0.02533f ; **FLOATING
C1857 VIN.n841 VSS 0.02533f ; **FLOATING
C1858 VIN.n842 VSS 0.02533f ; **FLOATING
C1859 VIN.n843 VSS 0.02533f ; **FLOATING
C1860 VIN.n844 VSS 0.02533f ; **FLOATING
C1861 VIN.n845 VSS 0.02533f ; **FLOATING
C1862 VIN.n846 VSS 0.02533f ; **FLOATING
C1863 VIN.n847 VSS 0.02533f ; **FLOATING
C1864 VIN.n848 VSS 0.02533f ; **FLOATING
C1865 VIN.n849 VSS 0.02533f ; **FLOATING
C1866 VIN.n850 VSS 0.02533f ; **FLOATING
C1867 VIN.n852 VSS 0.08111f ; **FLOATING
C1868 VIN.n853 VSS 0.01824f ; **FLOATING
C1869 VIN.n854 VSS 0.01824f ; **FLOATING
C1870 VIN.n855 VSS 0.01824f ; **FLOATING
C1871 VIN.n856 VSS 0.01824f ; **FLOATING
C1872 VIN.n857 VSS 0.01824f ; **FLOATING
C1873 VIN.n858 VSS 0.01824f ; **FLOATING
C1874 VIN.n859 VSS 0.01824f ; **FLOATING
C1875 VIN.n860 VSS 0.01824f ; **FLOATING
C1876 VIN.n861 VSS 0.01824f ; **FLOATING
C1877 VIN.n862 VSS 0.01824f ; **FLOATING
C1878 VIN.n863 VSS 0.01824f ; **FLOATING
C1879 VIN.n864 VSS 0.01824f ; **FLOATING
C1880 VIN.n865 VSS 0.01824f ; **FLOATING
C1881 VIN.n866 VSS 0.01824f ; **FLOATING
C1882 VIN.n867 VSS 0.01824f ; **FLOATING
C1883 VIN.n868 VSS 0.01824f ; **FLOATING
C1884 VIN.n869 VSS 0.08111f ; **FLOATING
C1885 VIN.n870 VSS 0.02058f ; **FLOATING
C1886 VIN.n871 VSS 0.59427f ; **FLOATING
C1887 VIN.n872 VSS 0.08111f ; **FLOATING
C1888 VIN.n873 VSS 0.38617f ; **FLOATING
C1889 VIN.n874 VSS 0.01824f ; **FLOATING
C1890 VIN.n875 VSS 0.54922f ; **FLOATING
C1891 VIN.n876 VSS 0.01824f ; **FLOATING
C1892 VIN.n877 VSS 0.50288f ; **FLOATING
C1893 VIN.n878 VSS 0.01824f ; **FLOATING
C1894 VIN.n879 VSS 0.32095f ; **FLOATING
C1895 VIN.n880 VSS 0.01824f ; **FLOATING
C1896 VIN.n881 VSS 0.54922f ; **FLOATING
C1897 VIN.n882 VSS 0.01824f ; **FLOATING
C1898 VIN.n883 VSS 0.53378f ; **FLOATING
C1899 VIN.n884 VSS 0.01824f ; **FLOATING
C1900 VIN.n885 VSS 0.29006f ; **FLOATING
C1901 VIN.n886 VSS 0.01824f ; **FLOATING
C1902 VIN.n887 VSS 0.54922f ; **FLOATING
C1903 VIN.n888 VSS 0.01824f ; **FLOATING
C1904 VIN.n889 VSS 0.54922f ; **FLOATING
C1905 VIN.n890 VSS 0.01824f ; **FLOATING
C1906 VIN.n891 VSS 0.29006f ; **FLOATING
C1907 VIN.n892 VSS 0.01824f ; **FLOATING
C1908 VIN.n893 VSS 0.53378f ; **FLOATING
C1909 VIN.n894 VSS 0.01824f ; **FLOATING
C1910 VIN.n895 VSS 0.54922f ; **FLOATING
C1911 VIN.n896 VSS 0.01824f ; **FLOATING
C1912 VIN.n897 VSS 0.32095f ; **FLOATING
C1913 VIN.n898 VSS 0.01824f ; **FLOATING
C1914 VIN.n899 VSS 0.50288f ; **FLOATING
C1915 VIN.n900 VSS 0.01824f ; **FLOATING
C1916 VIN.n901 VSS 0.54922f ; **FLOATING
C1917 VIN.n902 VSS 0.01824f ; **FLOATING
C1918 VIN.n903 VSS 0.38617f ; **FLOATING
C1919 VIN.n904 VSS 0.01824f ; **FLOATING
C1920 VIN.n905 VSS 0.59427f ; **FLOATING
C1921 VIN.t15 VSS 0.27461f ; **FLOATING
C1922 VIN.t32 VSS 0.27461f ; **FLOATING
C1923 VIN.t33 VSS 0.27461f ; **FLOATING
C1924 VIN.t45 VSS 0.27461f ; **FLOATING
C1925 VIN.t110 VSS 0.27461f ; **FLOATING
C1926 VIN.t106 VSS 0.27461f ; **FLOATING
C1927 VIN.n906 VSS 0.08111f ; **FLOATING
C1928 VIN.n907 VSS 0.02058f ; **FLOATING
C1929 VIN.n908 VSS 0.88193f ; **FLOATING
C1930 VIN.n909 VSS 0.17559f ; **FLOATING
C1931 VIN.n910 VSS 0.12625f ; **FLOATING
C1932 VIN.t105 VSS 0.0914f ; **FLOATING
C1933 VIN.n911 VSS 0.14762f ; **FLOATING
C1934 VIN.t108 VSS 0.0808f ; **FLOATING
C1935 VIN.t107 VSS 0.07597f ; **FLOATING
C1936 VIN.n912 VSS 0.12081f ; **FLOATING
C1937 VIN.n913 VSS 0.12519f ; **FLOATING
C1938 VIN.t109 VSS 0.0914f ; **FLOATING
C1939 VIN.n914 VSS 0.14762f ; **FLOATING
C1940 VIN.t112 VSS 0.07597f ; **FLOATING
C1941 VIN.n915 VSS 0.12081f ; **FLOATING
C1942 VIN.t111 VSS 0.0808f ; **FLOATING
C1943 VIN.n916 VSS 0.06571f ; **FLOATING
C1944 VIN.n917 VSS 0.02058f ; **FLOATING
C1945 VIN.n918 VSS 0.02802f ; **FLOATING
C1946 VIN.n919 VSS 0.06593f ; **FLOATING
C1947 VIN.n920 VSS 0.02533f ; **FLOATING
C1948 VIN.n921 VSS 0.02533f ; **FLOATING
C1949 VIN.n922 VSS 0.02533f ; **FLOATING
C1950 VIN.n923 VSS 0.02533f ; **FLOATING
C1951 VIN.n924 VSS 0.02533f ; **FLOATING
C1952 VIN.n925 VSS 0.02533f ; **FLOATING
C1953 VIN.n926 VSS 0.02533f ; **FLOATING
C1954 VIN.n927 VSS 0.02533f ; **FLOATING
C1955 VIN.n928 VSS 0.02533f ; **FLOATING
C1956 VIN.n929 VSS 0.02533f ; **FLOATING
C1957 VIN.n930 VSS 0.02533f ; **FLOATING
C1958 VIN.n931 VSS 0.02533f ; **FLOATING
C1959 VIN.n932 VSS 0.02533f ; **FLOATING
C1960 VIN.n933 VSS 0.02533f ; **FLOATING
C1961 VIN.n934 VSS 0.02533f ; **FLOATING
C1962 VIN.n935 VSS 0.02533f ; **FLOATING
C1963 VIN.n936 VSS 0.02533f ; **FLOATING
C1964 VIN.n937 VSS 0.02533f ; **FLOATING
C1965 VIN.n938 VSS 0.02533f ; **FLOATING
C1966 VIN.n939 VSS 0.02533f ; **FLOATING
C1967 VIN.n940 VSS 0.02533f ; **FLOATING
C1968 VIN.n941 VSS 0.02533f ; **FLOATING
C1969 VIN.n942 VSS 0.02533f ; **FLOATING
C1970 VIN.n943 VSS 0.02533f ; **FLOATING
C1971 VIN.n944 VSS 0.02533f ; **FLOATING
C1972 VIN.n945 VSS 0.02533f ; **FLOATING
C1973 VIN.n946 VSS 0.02533f ; **FLOATING
C1974 VIN.n947 VSS 0.02533f ; **FLOATING
C1975 VIN.n948 VSS 0.02533f ; **FLOATING
C1976 VIN.n949 VSS 0.02533f ; **FLOATING
C1977 VIN.n950 VSS 0.02533f ; **FLOATING
C1978 VIN.n951 VSS 0.02533f ; **FLOATING
C1979 VIN.n952 VSS 0.02533f ; **FLOATING
C1980 VIN.n953 VSS 0.02533f ; **FLOATING
C1981 VIN.n954 VSS 0.02533f ; **FLOATING
C1982 VIN.n955 VSS 0.02533f ; **FLOATING
C1983 VIN.n956 VSS 0.02533f ; **FLOATING
C1984 VIN.n957 VSS 0.02533f ; **FLOATING
C1985 VIN.n958 VSS 0.02533f ; **FLOATING
C1986 VIN.n959 VSS 0.02533f ; **FLOATING
C1987 VIN.n960 VSS 0.02533f ; **FLOATING
C1988 VIN.n961 VSS 0.02533f ; **FLOATING
C1989 VIN.n962 VSS 0.02533f ; **FLOATING
C1990 VIN.n963 VSS 0.02533f ; **FLOATING
C1991 VIN.n964 VSS 0.02533f ; **FLOATING
C1992 VIN.n965 VSS 0.02533f ; **FLOATING
C1993 VIN.n966 VSS 0.02533f ; **FLOATING
C1994 VIN.n967 VSS 0.02533f ; **FLOATING
C1995 VIN.n968 VSS 0.02533f ; **FLOATING
C1996 VIN.n969 VSS 0.02533f ; **FLOATING
C1997 VIN.n970 VSS 0.02533f ; **FLOATING
C1998 VIN.n971 VSS 0.02533f ; **FLOATING
C1999 VIN.n972 VSS 0.02533f ; **FLOATING
C2000 VIN.n973 VSS 0.02533f ; **FLOATING
C2001 VIN.n974 VSS 0.02533f ; **FLOATING
C2002 VIN.n975 VSS 0.02533f ; **FLOATING
C2003 VIN.n976 VSS 0.02533f ; **FLOATING
C2004 VIN.n977 VSS 0.02533f ; **FLOATING
C2005 VIN.n978 VSS 0.02533f ; **FLOATING
C2006 VIN.n979 VSS 0.02533f ; **FLOATING
C2007 VIN.n980 VSS 0.02533f ; **FLOATING
C2008 VIN.n981 VSS 0.02533f ; **FLOATING
C2009 VIN.n982 VSS 0.02533f ; **FLOATING
C2010 VIN.n983 VSS 0.02533f ; **FLOATING
C2011 VIN.n984 VSS 0.02533f ; **FLOATING
C2012 VIN.n985 VSS 0.02533f ; **FLOATING
C2013 VIN.n986 VSS 0.02533f ; **FLOATING
C2014 VIN.n987 VSS 0.02533f ; **FLOATING
C2015 VIN.n989 VSS 1.14939f ; **FLOATING
C2016 VIN.n990 VSS 0.22404f ; **FLOATING
C2017 VIN.n991 VSS 0.02058f ; **FLOATING
C2018 VIN.n992 VSS 0.08325f ; **FLOATING
C2019 VIN.n993 VSS 0.08325f ; **FLOATING
C2020 VIN.n994 VSS 0.02533f ; **FLOATING
C2021 VIN.n995 VSS 0.02533f ; **FLOATING
C2022 VIN.n996 VSS 0.02533f ; **FLOATING
C2023 VIN.n997 VSS 0.02533f ; **FLOATING
C2024 VIN.n998 VSS 0.02533f ; **FLOATING
C2025 VIN.n999 VSS 0.02533f ; **FLOATING
C2026 VIN.n1000 VSS 0.02533f ; **FLOATING
C2027 VIN.n1001 VSS 0.02533f ; **FLOATING
C2028 VIN.n1002 VSS 0.02533f ; **FLOATING
C2029 VIN.n1003 VSS 0.02533f ; **FLOATING
C2030 VIN.n1004 VSS 0.02533f ; **FLOATING
C2031 VIN.n1005 VSS 0.02533f ; **FLOATING
C2032 VIN.n1006 VSS 0.02533f ; **FLOATING
C2033 VIN.n1007 VSS 0.02533f ; **FLOATING
C2034 VIN.n1008 VSS 0.02533f ; **FLOATING
C2035 VIN.n1009 VSS 0.02533f ; **FLOATING
C2036 VIN.n1010 VSS 0.02533f ; **FLOATING
C2037 VIN.n1011 VSS 0.02533f ; **FLOATING
C2038 VIN.n1012 VSS 0.02533f ; **FLOATING
C2039 VIN.n1013 VSS 0.02533f ; **FLOATING
C2040 VIN.n1014 VSS 0.02533f ; **FLOATING
C2041 VIN.n1015 VSS 0.02533f ; **FLOATING
C2042 VIN.n1016 VSS 0.02533f ; **FLOATING
C2043 VIN.n1017 VSS 0.02533f ; **FLOATING
C2044 VIN.n1018 VSS 0.02533f ; **FLOATING
C2045 VIN.n1019 VSS 0.02533f ; **FLOATING
C2046 VIN.n1020 VSS 0.02533f ; **FLOATING
C2047 VIN.n1021 VSS 0.02533f ; **FLOATING
C2048 VIN.n1022 VSS 0.02533f ; **FLOATING
C2049 VIN.n1023 VSS 0.02533f ; **FLOATING
C2050 VIN.n1024 VSS 0.02533f ; **FLOATING
C2051 VIN.n1025 VSS 0.02533f ; **FLOATING
C2052 VIN.n1026 VSS 0.02533f ; **FLOATING
C2053 VIN.n1027 VSS 0.02533f ; **FLOATING
C2054 VIN.n1028 VSS 0.02533f ; **FLOATING
C2055 VIN.n1029 VSS 0.02533f ; **FLOATING
C2056 VIN.n1030 VSS 0.02533f ; **FLOATING
C2057 VIN.n1031 VSS 0.02533f ; **FLOATING
C2058 VIN.n1032 VSS 0.02533f ; **FLOATING
C2059 VIN.n1033 VSS 0.02533f ; **FLOATING
C2060 VIN.n1034 VSS 0.02533f ; **FLOATING
C2061 VIN.n1035 VSS 0.02533f ; **FLOATING
C2062 VIN.n1036 VSS 0.02533f ; **FLOATING
C2063 VIN.n1037 VSS 0.02533f ; **FLOATING
C2064 VIN.n1038 VSS 0.02533f ; **FLOATING
C2065 VIN.n1039 VSS 0.02533f ; **FLOATING
C2066 VIN.n1040 VSS 0.02533f ; **FLOATING
C2067 VIN.n1041 VSS 0.02533f ; **FLOATING
C2068 VIN.n1042 VSS 0.02533f ; **FLOATING
C2069 VIN.n1043 VSS 0.02533f ; **FLOATING
C2070 VIN.n1044 VSS 0.02533f ; **FLOATING
C2071 VIN.n1045 VSS 0.02533f ; **FLOATING
C2072 VIN.n1046 VSS 0.02533f ; **FLOATING
C2073 VIN.n1047 VSS 0.02533f ; **FLOATING
C2074 VIN.n1048 VSS 0.02533f ; **FLOATING
C2075 VIN.n1049 VSS 0.02533f ; **FLOATING
C2076 VIN.n1050 VSS 0.02533f ; **FLOATING
C2077 VIN.n1051 VSS 0.02533f ; **FLOATING
C2078 VIN.n1052 VSS 0.02533f ; **FLOATING
C2079 VIN.n1053 VSS 0.02533f ; **FLOATING
C2080 VIN.n1054 VSS 0.02533f ; **FLOATING
C2081 VIN.n1055 VSS 0.02533f ; **FLOATING
C2082 VIN.n1056 VSS 0.02533f ; **FLOATING
C2083 VIN.n1057 VSS 0.02533f ; **FLOATING
C2084 VIN.n1058 VSS 0.02533f ; **FLOATING
C2085 VIN.n1059 VSS 0.02533f ; **FLOATING
C2086 VIN.n1060 VSS 0.02533f ; **FLOATING
C2087 VIN.n1061 VSS 0.02533f ; **FLOATING
C2088 VIN.n1063 VSS 0.09721f ; **FLOATING
C2089 VIN.n1064 VSS 0.01824f ; **FLOATING
C2090 VIN.n1065 VSS 0.01824f ; **FLOATING
C2091 VIN.n1066 VSS 0.01824f ; **FLOATING
C2092 VIN.n1067 VSS 0.01824f ; **FLOATING
C2093 VIN.n1068 VSS 0.01824f ; **FLOATING
C2094 VIN.n1069 VSS 0.01824f ; **FLOATING
C2095 VIN.n1070 VSS 0.01824f ; **FLOATING
C2096 VIN.n1071 VSS 0.01824f ; **FLOATING
C2097 VIN.n1072 VSS 0.01824f ; **FLOATING
C2098 VIN.n1073 VSS 0.01824f ; **FLOATING
C2099 VIN.n1074 VSS 0.01824f ; **FLOATING
C2100 VIN.n1075 VSS 0.01824f ; **FLOATING
C2101 VIN.n1076 VSS 0.01824f ; **FLOATING
C2102 VIN.n1077 VSS 0.01824f ; **FLOATING
C2103 VIN.n1078 VSS 0.01824f ; **FLOATING
C2104 VIN.n1079 VSS 0.01824f ; **FLOATING
C2105 VIN.n1080 VSS 0.01824f ; **FLOATING
C2106 VIN.n1081 VSS 0.01824f ; **FLOATING
C2107 VIN.n1082 VSS 0.01824f ; **FLOATING
C2108 VIN.n1083 VSS 0.01824f ; **FLOATING
C2109 VIN.n1084 VSS 0.01824f ; **FLOATING
C2110 VIN.n1085 VSS 0.01824f ; **FLOATING
C2111 VIN.n1086 VSS 0.01824f ; **FLOATING
C2112 VIN.n1087 VSS 0.01824f ; **FLOATING
C2113 VIN.n1088 VSS 0.01824f ; **FLOATING
C2114 VIN.n1089 VSS 0.01824f ; **FLOATING
C2115 VIN.n1090 VSS 0.01824f ; **FLOATING
C2116 VIN.n1091 VSS 0.01824f ; **FLOATING
C2117 VIN.n1092 VSS 0.01824f ; **FLOATING
C2118 VIN.n1093 VSS 0.01824f ; **FLOATING
C2119 VIN.n1094 VSS 0.01824f ; **FLOATING
C2120 VIN.n1095 VSS 0.01824f ; **FLOATING
C2121 VIN.n1096 VSS 0.01824f ; **FLOATING
C2122 VIN.n1097 VSS 0.01824f ; **FLOATING
C2123 VIN.n1098 VSS 0.09721f ; **FLOATING
C2124 VIN.n1099 VSS 0.02058f ; **FLOATING
C2125 VIN.n1100 VSS 0.93249f ; **FLOATING
C2126 VIN.n1101 VSS 0.09721f ; **FLOATING
C2127 VIN.n1102 VSS 0.65526f ; **FLOATING
C2128 VIN.n1103 VSS 0.01824f ; **FLOATING
C2129 VIN.n1104 VSS 0.35933f ; **FLOATING
C2130 VIN.n1105 VSS 0.01824f ; **FLOATING
C2131 VIN.n1106 VSS 0.6764f ; **FLOATING
C2132 VIN.n1107 VSS 0.01824f ; **FLOATING
C2133 VIN.n1108 VSS 0.6764f ; **FLOATING
C2134 VIN.n1109 VSS 0.01824f ; **FLOATING
C2135 VIN.n1110 VSS 0.6764f ; **FLOATING
C2136 VIN.n1111 VSS 0.01824f ; **FLOATING
C2137 VIN.n1112 VSS 0.6764f ; **FLOATING
C2138 VIN.n1113 VSS 0.01824f ; **FLOATING
C2139 VIN.n1114 VSS 0.6764f ; **FLOATING
C2140 VIN.n1115 VSS 0.01824f ; **FLOATING
C2141 VIN.n1116 VSS 0.41852f ; **FLOATING
C2142 VIN.n1117 VSS 0.01824f ; **FLOATING
C2143 VIN.n1118 VSS 0.59607f ; **FLOATING
C2144 VIN.n1119 VSS 0.01824f ; **FLOATING
C2145 VIN.n1120 VSS 0.6764f ; **FLOATING
C2146 VIN.n1121 VSS 0.01824f ; **FLOATING
C2147 VIN.n1122 VSS 0.6764f ; **FLOATING
C2148 VIN.n1123 VSS 0.01824f ; **FLOATING
C2149 VIN.n1124 VSS 0.6764f ; **FLOATING
C2150 VIN.n1125 VSS 0.01824f ; **FLOATING
C2151 VIN.n1126 VSS 0.6764f ; **FLOATING
C2152 VIN.n1127 VSS 0.01824f ; **FLOATING
C2153 VIN.n1128 VSS 0.4777f ; **FLOATING
C2154 VIN.n1129 VSS 0.01824f ; **FLOATING
C2155 VIN.n1130 VSS 0.53689f ; **FLOATING
C2156 VIN.n1131 VSS 0.01824f ; **FLOATING
C2157 VIN.n1132 VSS 0.6764f ; **FLOATING
C2158 VIN.n1133 VSS 0.01824f ; **FLOATING
C2159 VIN.n1134 VSS 0.6764f ; **FLOATING
C2160 VIN.n1135 VSS 0.01824f ; **FLOATING
C2161 VIN.n1136 VSS 0.6764f ; **FLOATING
C2162 VIN.n1137 VSS 0.01824f ; **FLOATING
C2163 VIN.n1138 VSS 0.6764f ; **FLOATING
C2164 VIN.n1139 VSS 0.01824f ; **FLOATING
C2165 VIN.n1140 VSS 0.53689f ; **FLOATING
C2166 VIN.n1141 VSS 0.01824f ; **FLOATING
C2167 VIN.n1142 VSS 0.4777f ; **FLOATING
C2168 VIN.n1143 VSS 0.01824f ; **FLOATING
C2169 VIN.n1144 VSS 0.6764f ; **FLOATING
C2170 VIN.n1145 VSS 0.01824f ; **FLOATING
C2171 VIN.n1146 VSS 0.6764f ; **FLOATING
C2172 VIN.n1147 VSS 0.01824f ; **FLOATING
C2173 VIN.n1148 VSS 0.6764f ; **FLOATING
C2174 VIN.n1149 VSS 0.01824f ; **FLOATING
C2175 VIN.n1150 VSS 0.6764f ; **FLOATING
C2176 VIN.n1151 VSS 0.01824f ; **FLOATING
C2177 VIN.n1152 VSS 0.59607f ; **FLOATING
C2178 VIN.n1153 VSS 0.01824f ; **FLOATING
C2179 VIN.n1154 VSS 0.41852f ; **FLOATING
C2180 VIN.n1155 VSS 0.01824f ; **FLOATING
C2181 VIN.n1156 VSS 0.6764f ; **FLOATING
C2182 VIN.n1157 VSS 0.01824f ; **FLOATING
C2183 VIN.n1158 VSS 0.6764f ; **FLOATING
C2184 VIN.n1159 VSS 0.01824f ; **FLOATING
C2185 VIN.n1160 VSS 0.6764f ; **FLOATING
C2186 VIN.n1161 VSS 0.01824f ; **FLOATING
C2187 VIN.n1162 VSS 0.6764f ; **FLOATING
C2188 VIN.n1163 VSS 0.01824f ; **FLOATING
C2189 VIN.n1164 VSS 0.6764f ; **FLOATING
C2190 VIN.n1165 VSS 0.01824f ; **FLOATING
C2191 VIN.n1166 VSS 0.35933f ; **FLOATING
C2192 VIN.n1167 VSS 0.01824f ; **FLOATING
C2193 VIN.n1168 VSS 0.65526f ; **FLOATING
C2194 VIN.n1169 VSS 0.01824f ; **FLOATING
C2195 VIN.n1170 VSS 0.93249f ; **FLOATING
C2196 VIN.t24 VSS 0.3382f ; **FLOATING
C2197 VIN.t173 VSS 0.3382f ; **FLOATING
C2198 VIN.t249 VSS 0.3382f ; **FLOATING
C2199 VIN.t274 VSS 0.3382f ; **FLOATING
C2200 VIN.t118 VSS 0.3382f ; **FLOATING
C2201 VIN.t114 VSS 0.3382f ; **FLOATING
C2202 VIN.n1171 VSS 0.09721f ; **FLOATING
C2203 VIN.n1172 VSS 0.02058f ; **FLOATING
C2204 VIN.n1173 VSS 1.14939f ; **FLOATING
C2205 VIN.n1174 VSS 0.22404f ; **FLOATING
C2206 VIN.n1175 VSS 0.14492f ; **FLOATING
C2207 VIN.t113 VSS 0.96442f ; **FLOATING
C2208 VIN.n1176 VSS 0.28937f ; **FLOATING
C2209 VIN.t116 VSS 0.22161f ; **FLOATING
C2210 VIN.t115 VSS 0.18753f ; **FLOATING
C2211 VIN.n1177 VSS 0.19176f ; **FLOATING
C2212 VIN.n1178 VSS 0.14359f ; **FLOATING
C2213 VIN.t117 VSS 0.96442f ; **FLOATING
C2214 VIN.n1179 VSS 0.28937f ; **FLOATING
C2215 VIN.t120 VSS 0.18753f ; **FLOATING
C2216 VIN.n1180 VSS 0.19176f ; **FLOATING
C2217 VIN.t119 VSS 0.22161f ; **FLOATING
C2218 VIN.n1181 VSS 0.42246f ; **FLOATING
C2219 VIN.n1182 VSS 2.70923f ; **FLOATING
C2220 VIN.n1183 VSS 5.58369f ; **FLOATING
C2221 VIN.n1184 VSS 5.27435f ; **FLOATING
C2222 VIN.n1185 VSS 5.08815f ; **FLOATING
C2223 VIN.n1186 VSS 5.08815f ; **FLOATING
C2224 VIN.n1187 VSS 12.3121f ; **FLOATING
C2225 VIN.n1188 VSS 3.43227f ; **FLOATING
C2226 VIN.n1189 VSS 1.06045f ; **FLOATING
C2227 VIN.n1190 VSS 1.06045f ; **FLOATING
C2228 VIN.n1191 VSS 1.06045f ; **FLOATING
C2229 VIN.n1192 VSS 1.06045f ; **FLOATING
C2230 VIN.n1193 VSS 1.58945f ; **FLOATING
C2231 VIN.t3 VSS 0.26537f ; **FLOATING
C2232 VIN.n1194 VSS 0.16286f ; **FLOATING
C2233 VIN.t29 VSS 0.0266f ; **FLOATING
C2234 VIN.t267 VSS 0.0266f ; **FLOATING
C2235 VIN.n1195 VSS 0.2307f ; **FLOATING
C2236 VIN.n1196 VSS 0.07991f ; **FLOATING
C2237 VIN.n1197 VSS 0.13929f ; **FLOATING
C2238 VIN.n1198 VSS 0.13929f ; **FLOATING
C2239 VIN.n1199 VSS 0.13929f ; **FLOATING
C2240 VIN.n1200 VSS 0.13929f ; **FLOATING
C2241 VIN.n1201 VSS 0.28356f ; **FLOATING
C2242 VIN.n1202 VSS 0.19708f ; **FLOATING
C2243 VIN.n1203 VSS 0.19708f ; **FLOATING
C2244 VIN.n1204 VSS 0.19708f ; **FLOATING
C2245 VIN.t152 VSS 0.26537f ; **FLOATING
C2246 VIN.n1205 VSS 0.14235f ; **FLOATING
C2247 VIN.t151 VSS 0.0266f ; **FLOATING
C2248 VIN.t150 VSS 0.0266f ; **FLOATING
C2249 VIN.n1206 VSS 0.2307f ; **FLOATING
C2250 VIN.n1207 VSS 0.07991f ; **FLOATING
C2251 VIN.n1208 VSS 0.07632f ; **FLOATING
C2252 VIN.n1209 VSS 0.07632f ; **FLOATING
C2253 VIN.n1210 VSS 0.07632f ; **FLOATING
C2254 VIN.n1211 VSS 0.07632f ; **FLOATING
C2255 VIN.n1212 VSS 3.14746f ; **FLOATING
C2256 VIN.n1213 VSS 1.06045f ; **FLOATING
C2257 VIN.n1214 VSS 1.06045f ; **FLOATING
C2258 VIN.n1215 VSS 1.06045f ; **FLOATING
C2259 VIN.t179 VSS 0.26537f ; **FLOATING
C2260 VIN.n1216 VSS 0.14235f ; **FLOATING
C2261 VIN.t186 VSS 0.0266f ; **FLOATING
C2262 VIN.t185 VSS 0.0266f ; **FLOATING
C2263 VIN.n1217 VSS 0.2307f ; **FLOATING
C2264 VIN.n1218 VSS 0.07991f ; **FLOATING
C2265 VIN.n1219 VSS 0.07632f ; **FLOATING
C2266 VIN.n1220 VSS 0.07632f ; **FLOATING
C2267 VIN.n1221 VSS 0.07632f ; **FLOATING
C2268 VIN.n1222 VSS 3.14746f ; **FLOATING
C2269 VIN.n1223 VSS 1.06045f ; **FLOATING
C2270 VIN.n1224 VSS 1.06045f ; **FLOATING
C2271 VIN.t71 VSS 0.26537f ; **FLOATING
C2272 VIN.n1225 VSS 0.14235f ; **FLOATING
C2273 VIN.t70 VSS 0.0266f ; **FLOATING
C2274 VIN.t69 VSS 0.0266f ; **FLOATING
C2275 VIN.n1226 VSS 0.2307f ; **FLOATING
C2276 VIN.n1227 VSS 0.07991f ; **FLOATING
C2277 VIN.n1228 VSS 0.07632f ; **FLOATING
C2278 VIN.n1229 VSS 0.07632f ; **FLOATING
C2279 VIN.n1230 VSS 3.14746f ; **FLOATING
C2280 VIN.n1231 VSS 1.06045f ; **FLOATING
C2281 VIN.t87 VSS 0.26537f ; **FLOATING
C2282 VIN.n1232 VSS 0.14235f ; **FLOATING
C2283 VIN.t230 VSS 0.0266f ; **FLOATING
C2284 VIN.t229 VSS 0.0266f ; **FLOATING
C2285 VIN.n1233 VSS 0.2307f ; **FLOATING
C2286 VIN.n1234 VSS 0.07991f ; **FLOATING
C2287 VIN.n1235 VSS 0.07632f ; **FLOATING
C2288 VIN.t222 VSS 0.26537f ; **FLOATING
C2289 VIN.n1236 VSS 0.16286f ; **FLOATING
C2290 VIN.t226 VSS 0.0266f ; **FLOATING
C2291 VIN.t225 VSS 0.0266f ; **FLOATING
C2292 VIN.n1237 VSS 0.2307f ; **FLOATING
C2293 VIN.n1238 VSS 0.07991f ; **FLOATING
C2294 VIN.n1239 VSS 0.07632f ; **FLOATING
C2295 VIN.n1240 VSS 0.07632f ; **FLOATING
C2296 VIN.n1241 VSS 0.07632f ; **FLOATING
C2297 VIN.n1242 VSS 0.07632f ; **FLOATING
C2298 VIN.t224 VSS 0.0266f ; **FLOATING
C2299 VIN.t223 VSS 0.0266f ; **FLOATING
C2300 VIN.n1243 VSS 0.2307f ; **FLOATING
C2301 VIN.n1244 VSS 0.11237f ; **FLOATING
C2302 VIN.t137 VSS 0.0266f ; **FLOATING
C2303 VIN.t136 VSS 0.0266f ; **FLOATING
C2304 VIN.n1245 VSS 0.2307f ; **FLOATING
C2305 VIN.n1246 VSS 0.10556f ; **FLOATING
C2306 VIN.t135 VSS 0.0266f ; **FLOATING
C2307 VIN.t134 VSS 0.0266f ; **FLOATING
C2308 VIN.n1247 VSS 0.2307f ; **FLOATING
C2309 VIN.n1248 VSS 0.08403f ; **FLOATING
C2310 VIN.t255 VSS 0.0266f ; **FLOATING
C2311 VIN.t254 VSS 0.0266f ; **FLOATING
C2312 VIN.n1249 VSS 0.2307f ; **FLOATING
C2313 VIN.n1250 VSS 0.11237f ; **FLOATING
C2314 VIN.t253 VSS 0.0266f ; **FLOATING
C2315 VIN.t252 VSS 0.0266f ; **FLOATING
C2316 VIN.n1251 VSS 0.2307f ; **FLOATING
C2317 VIN.n1252 VSS 0.10145f ; **FLOATING
C2318 VIN.t128 VSS 0.0266f ; **FLOATING
C2319 VIN.t127 VSS 0.0266f ; **FLOATING
C2320 VIN.n1253 VSS 0.2307f ; **FLOATING
C2321 VIN.n1254 VSS 0.08815f ; **FLOATING
C2322 VIN.t126 VSS 0.0266f ; **FLOATING
C2323 VIN.t125 VSS 0.0266f ; **FLOATING
C2324 VIN.n1255 VSS 0.2307f ; **FLOATING
C2325 VIN.n1256 VSS 0.11237f ; **FLOATING
C2326 VIN.t94 VSS 0.0266f ; **FLOATING
C2327 VIN.t93 VSS 0.0266f ; **FLOATING
C2328 VIN.n1257 VSS 0.2307f ; **FLOATING
C2329 VIN.n1258 VSS 0.09733f ; **FLOATING
C2330 VIN.t92 VSS 0.0266f ; **FLOATING
C2331 VIN.t91 VSS 0.0266f ; **FLOATING
C2332 VIN.n1259 VSS 0.2307f ; **FLOATING
C2333 VIN.n1260 VSS 0.09226f ; **FLOATING
C2334 VIN.t234 VSS 0.0266f ; **FLOATING
C2335 VIN.t233 VSS 0.0266f ; **FLOATING
C2336 VIN.n1261 VSS 0.2307f ; **FLOATING
C2337 VIN.n1262 VSS 0.11237f ; **FLOATING
C2338 VIN.t232 VSS 0.0266f ; **FLOATING
C2339 VIN.t231 VSS 0.0266f ; **FLOATING
C2340 VIN.n1263 VSS 0.2307f ; **FLOATING
C2341 VIN.n1264 VSS 0.09321f ; **FLOATING
C2342 VIN.t86 VSS 0.0266f ; **FLOATING
C2343 VIN.t85 VSS 0.0266f ; **FLOATING
C2344 VIN.n1265 VSS 0.2307f ; **FLOATING
C2345 VIN.n1266 VSS 0.09638f ; **FLOATING
C2346 VIN.t84 VSS 0.0266f ; **FLOATING
C2347 VIN.t83 VSS 0.0266f ; **FLOATING
C2348 VIN.n1267 VSS 0.2307f ; **FLOATING
C2349 VIN.n1268 VSS 0.21731f ; **FLOATING
C2350 VIN.t78 VSS 0.2717f ; **FLOATING
C2351 VIN.n1269 VSS 0.07632f ; **FLOATING
C2352 VIN.n1270 VSS 3.14746f ; **FLOATING
C2353 VIN.t77 VSS 0.26537f ; **FLOATING
C2354 VIN.n1271 VSS 0.14235f ; **FLOATING
C2355 VIN.t76 VSS 0.0266f ; **FLOATING
C2356 VIN.t75 VSS 0.0266f ; **FLOATING
C2357 VIN.n1272 VSS 0.2307f ; **FLOATING
C2358 VIN.n1273 VSS 0.07991f ; **FLOATING
C2359 VIN.n1274 VSS 0.07632f ; **FLOATING
C2360 VIN.n1275 VSS 0.07632f ; **FLOATING
C2361 VIN.n1276 VSS 0.07632f ; **FLOATING
C2362 VIN.n1277 VSS 0.07632f ; **FLOATING
C2363 VIN.t242 VSS 0.0266f ; **FLOATING
C2364 VIN.t241 VSS 0.0266f ; **FLOATING
C2365 VIN.n1278 VSS 0.2307f ; **FLOATING
C2366 VIN.n1279 VSS 0.11237f ; **FLOATING
C2367 VIN.t240 VSS 0.0266f ; **FLOATING
C2368 VIN.t239 VSS 0.0266f ; **FLOATING
C2369 VIN.n1280 VSS 0.2307f ; **FLOATING
C2370 VIN.n1281 VSS 0.10556f ; **FLOATING
C2371 VIN.t133 VSS 0.0266f ; **FLOATING
C2372 VIN.t131 VSS 0.0266f ; **FLOATING
C2373 VIN.n1282 VSS 0.2307f ; **FLOATING
C2374 VIN.n1283 VSS 0.08403f ; **FLOATING
C2375 VIN.t130 VSS 0.0266f ; **FLOATING
C2376 VIN.t129 VSS 0.0266f ; **FLOATING
C2377 VIN.n1284 VSS 0.2307f ; **FLOATING
C2378 VIN.n1285 VSS 0.11237f ; **FLOATING
C2379 VIN.t98 VSS 0.0266f ; **FLOATING
C2380 VIN.t97 VSS 0.0266f ; **FLOATING
C2381 VIN.n1286 VSS 0.2307f ; **FLOATING
C2382 VIN.n1287 VSS 0.10145f ; **FLOATING
C2383 VIN.t96 VSS 0.0266f ; **FLOATING
C2384 VIN.t95 VSS 0.0266f ; **FLOATING
C2385 VIN.n1288 VSS 0.2307f ; **FLOATING
C2386 VIN.n1289 VSS 0.08815f ; **FLOATING
C2387 VIN.t246 VSS 0.0266f ; **FLOATING
C2388 VIN.t245 VSS 0.0266f ; **FLOATING
C2389 VIN.n1290 VSS 0.2307f ; **FLOATING
C2390 VIN.n1291 VSS 0.11237f ; **FLOATING
C2391 VIN.t244 VSS 0.0266f ; **FLOATING
C2392 VIN.t243 VSS 0.0266f ; **FLOATING
C2393 VIN.n1292 VSS 0.2307f ; **FLOATING
C2394 VIN.n1293 VSS 0.09733f ; **FLOATING
C2395 VIN.t124 VSS 0.0266f ; **FLOATING
C2396 VIN.t123 VSS 0.0266f ; **FLOATING
C2397 VIN.n1294 VSS 0.2307f ; **FLOATING
C2398 VIN.n1295 VSS 0.09226f ; **FLOATING
C2399 VIN.t122 VSS 0.0266f ; **FLOATING
C2400 VIN.t121 VSS 0.0266f ; **FLOATING
C2401 VIN.n1296 VSS 0.2307f ; **FLOATING
C2402 VIN.n1297 VSS 0.11237f ; **FLOATING
C2403 VIN.t82 VSS 0.0266f ; **FLOATING
C2404 VIN.t81 VSS 0.0266f ; **FLOATING
C2405 VIN.n1298 VSS 0.2307f ; **FLOATING
C2406 VIN.n1299 VSS 0.09321f ; **FLOATING
C2407 VIN.t80 VSS 0.0266f ; **FLOATING
C2408 VIN.t79 VSS 0.0266f ; **FLOATING
C2409 VIN.n1300 VSS 0.2307f ; **FLOATING
C2410 VIN.n1301 VSS 0.09638f ; **FLOATING
C2411 VIN.t90 VSS 0.0266f ; **FLOATING
C2412 VIN.t89 VSS 0.0266f ; **FLOATING
C2413 VIN.n1302 VSS 0.2307f ; **FLOATING
C2414 VIN.n1303 VSS 0.21731f ; **FLOATING
C2415 VIN.t88 VSS 0.2717f ; **FLOATING
C2416 VIN.n1304 VSS 0.07632f ; **FLOATING
C2417 VIN.n1305 VSS 1.06045f ; **FLOATING
C2418 VIN.n1306 VSS 1.06045f ; **FLOATING
C2419 VIN.n1307 VSS 1.06045f ; **FLOATING
C2420 VIN.n1308 VSS 1.58945f ; **FLOATING
C2421 VIN.n1309 VSS 1.06045f ; **FLOATING
C2422 VIN.n1310 VSS 0.07632f ; **FLOATING
C2423 VIN.n1311 VSS 0.07632f ; **FLOATING
C2424 VIN.n1312 VSS 0.07632f ; **FLOATING
C2425 VIN.t228 VSS 0.0266f ; **FLOATING
C2426 VIN.t227 VSS 0.0266f ; **FLOATING
C2427 VIN.n1313 VSS 0.2307f ; **FLOATING
C2428 VIN.n1314 VSS 0.11237f ; **FLOATING
C2429 VIN.t259 VSS 0.0266f ; **FLOATING
C2430 VIN.t258 VSS 0.0266f ; **FLOATING
C2431 VIN.n1315 VSS 0.2307f ; **FLOATING
C2432 VIN.n1316 VSS 0.10556f ; **FLOATING
C2433 VIN.t257 VSS 0.0266f ; **FLOATING
C2434 VIN.t256 VSS 0.0266f ; **FLOATING
C2435 VIN.n1317 VSS 0.2307f ; **FLOATING
C2436 VIN.n1318 VSS 0.08403f ; **FLOATING
C2437 VIN.t55 VSS 0.0266f ; **FLOATING
C2438 VIN.t54 VSS 0.0266f ; **FLOATING
C2439 VIN.n1319 VSS 0.2307f ; **FLOATING
C2440 VIN.n1320 VSS 0.11237f ; **FLOATING
C2441 VIN.t52 VSS 0.0266f ; **FLOATING
C2442 VIN.t50 VSS 0.0266f ; **FLOATING
C2443 VIN.n1321 VSS 0.2307f ; **FLOATING
C2444 VIN.n1322 VSS 0.10145f ; **FLOATING
C2445 VIN.t64 VSS 0.0266f ; **FLOATING
C2446 VIN.t63 VSS 0.0266f ; **FLOATING
C2447 VIN.n1323 VSS 0.2307f ; **FLOATING
C2448 VIN.n1324 VSS 0.08815f ; **FLOATING
C2449 VIN.t61 VSS 0.0266f ; **FLOATING
C2450 VIN.t60 VSS 0.0266f ; **FLOATING
C2451 VIN.n1325 VSS 0.2307f ; **FLOATING
C2452 VIN.n1326 VSS 0.11237f ; **FLOATING
C2453 VIN.t273 VSS 0.0266f ; **FLOATING
C2454 VIN.t272 VSS 0.0266f ; **FLOATING
C2455 VIN.n1327 VSS 0.2307f ; **FLOATING
C2456 VIN.n1328 VSS 0.09733f ; **FLOATING
C2457 VIN.t271 VSS 0.0266f ; **FLOATING
C2458 VIN.t270 VSS 0.0266f ; **FLOATING
C2459 VIN.n1329 VSS 0.2307f ; **FLOATING
C2460 VIN.n1330 VSS 0.09226f ; **FLOATING
C2461 VIN.t169 VSS 0.0266f ; **FLOATING
C2462 VIN.t168 VSS 0.0266f ; **FLOATING
C2463 VIN.n1331 VSS 0.2307f ; **FLOATING
C2464 VIN.n1332 VSS 0.11237f ; **FLOATING
C2465 VIN.t167 VSS 0.0266f ; **FLOATING
C2466 VIN.t166 VSS 0.0266f ; **FLOATING
C2467 VIN.n1333 VSS 0.2307f ; **FLOATING
C2468 VIN.n1334 VSS 0.09321f ; **FLOATING
C2469 VIN.t102 VSS 0.0266f ; **FLOATING
C2470 VIN.t101 VSS 0.0266f ; **FLOATING
C2471 VIN.n1335 VSS 0.2307f ; **FLOATING
C2472 VIN.n1336 VSS 0.09638f ; **FLOATING
C2473 VIN.t100 VSS 0.0266f ; **FLOATING
C2474 VIN.t99 VSS 0.0266f ; **FLOATING
C2475 VIN.n1337 VSS 0.2307f ; **FLOATING
C2476 VIN.n1338 VSS 0.21731f ; **FLOATING
C2477 VIN.t72 VSS 0.2717f ; **FLOATING
C2478 VIN.n1339 VSS 0.07632f ; **FLOATING
C2479 VIN.n1340 VSS 1.06045f ; **FLOATING
C2480 VIN.n1341 VSS 1.06045f ; **FLOATING
C2481 VIN.n1342 VSS 1.58945f ; **FLOATING
C2482 VIN.n1343 VSS 1.06045f ; **FLOATING
C2483 VIN.n1344 VSS 0.07632f ; **FLOATING
C2484 VIN.n1345 VSS 0.07632f ; **FLOATING
C2485 VIN.t206 VSS 0.0266f ; **FLOATING
C2486 VIN.t205 VSS 0.0266f ; **FLOATING
C2487 VIN.n1346 VSS 0.2307f ; **FLOATING
C2488 VIN.n1347 VSS 0.11237f ; **FLOATING
C2489 VIN.t204 VSS 0.0266f ; **FLOATING
C2490 VIN.t203 VSS 0.0266f ; **FLOATING
C2491 VIN.n1348 VSS 0.2307f ; **FLOATING
C2492 VIN.n1349 VSS 0.10556f ; **FLOATING
C2493 VIN.t198 VSS 0.0266f ; **FLOATING
C2494 VIN.t197 VSS 0.0266f ; **FLOATING
C2495 VIN.n1350 VSS 0.2307f ; **FLOATING
C2496 VIN.n1351 VSS 0.08403f ; **FLOATING
C2497 VIN.t196 VSS 0.0266f ; **FLOATING
C2498 VIN.t195 VSS 0.0266f ; **FLOATING
C2499 VIN.n1352 VSS 0.2307f ; **FLOATING
C2500 VIN.n1353 VSS 0.11237f ; **FLOATING
C2501 VIN.t210 VSS 0.0266f ; **FLOATING
C2502 VIN.t209 VSS 0.0266f ; **FLOATING
C2503 VIN.n1354 VSS 0.2307f ; **FLOATING
C2504 VIN.n1355 VSS 0.10145f ; **FLOATING
C2505 VIN.t208 VSS 0.0266f ; **FLOATING
C2506 VIN.t207 VSS 0.0266f ; **FLOATING
C2507 VIN.n1356 VSS 0.2307f ; **FLOATING
C2508 VIN.n1357 VSS 0.08815f ; **FLOATING
C2509 VIN.t178 VSS 0.0266f ; **FLOATING
C2510 VIN.t177 VSS 0.0266f ; **FLOATING
C2511 VIN.n1358 VSS 0.2307f ; **FLOATING
C2512 VIN.n1359 VSS 0.11237f ; **FLOATING
C2513 VIN.t176 VSS 0.0266f ; **FLOATING
C2514 VIN.t175 VSS 0.0266f ; **FLOATING
C2515 VIN.n1360 VSS 0.2307f ; **FLOATING
C2516 VIN.n1361 VSS 0.09733f ; **FLOATING
C2517 VIN.t215 VSS 0.0266f ; **FLOATING
C2518 VIN.t214 VSS 0.0266f ; **FLOATING
C2519 VIN.n1362 VSS 0.2307f ; **FLOATING
C2520 VIN.n1363 VSS 0.09226f ; **FLOATING
C2521 VIN.t213 VSS 0.0266f ; **FLOATING
C2522 VIN.t212 VSS 0.0266f ; **FLOATING
C2523 VIN.n1364 VSS 0.2307f ; **FLOATING
C2524 VIN.n1365 VSS 0.11237f ; **FLOATING
C2525 VIN.t190 VSS 0.0266f ; **FLOATING
C2526 VIN.t189 VSS 0.0266f ; **FLOATING
C2527 VIN.n1366 VSS 0.2307f ; **FLOATING
C2528 VIN.n1367 VSS 0.09321f ; **FLOATING
C2529 VIN.t188 VSS 0.0266f ; **FLOATING
C2530 VIN.t187 VSS 0.0266f ; **FLOATING
C2531 VIN.n1368 VSS 0.2307f ; **FLOATING
C2532 VIN.n1369 VSS 0.09638f ; **FLOATING
C2533 VIN.t182 VSS 0.0266f ; **FLOATING
C2534 VIN.t181 VSS 0.0266f ; **FLOATING
C2535 VIN.n1370 VSS 0.2307f ; **FLOATING
C2536 VIN.n1371 VSS 0.21731f ; **FLOATING
C2537 VIN.t180 VSS 0.2717f ; **FLOATING
C2538 VIN.n1372 VSS 0.07632f ; **FLOATING
C2539 VIN.n1373 VSS 1.06045f ; **FLOATING
C2540 VIN.n1374 VSS 1.58945f ; **FLOATING
C2541 VIN.n1375 VSS 1.06045f ; **FLOATING
C2542 VIN.n1376 VSS 0.07632f ; **FLOATING
C2543 VIN.t184 VSS 0.0266f ; **FLOATING
C2544 VIN.t183 VSS 0.0266f ; **FLOATING
C2545 VIN.n1377 VSS 0.2307f ; **FLOATING
C2546 VIN.n1378 VSS 0.11237f ; **FLOATING
C2547 VIN.t202 VSS 0.0266f ; **FLOATING
C2548 VIN.t201 VSS 0.0266f ; **FLOATING
C2549 VIN.n1379 VSS 0.2307f ; **FLOATING
C2550 VIN.n1380 VSS 0.10556f ; **FLOATING
C2551 VIN.t200 VSS 0.0266f ; **FLOATING
C2552 VIN.t199 VSS 0.0266f ; **FLOATING
C2553 VIN.n1381 VSS 0.2307f ; **FLOATING
C2554 VIN.n1382 VSS 0.08403f ; **FLOATING
C2555 VIN.t194 VSS 0.0266f ; **FLOATING
C2556 VIN.t193 VSS 0.0266f ; **FLOATING
C2557 VIN.n1383 VSS 0.2307f ; **FLOATING
C2558 VIN.n1384 VSS 0.11237f ; **FLOATING
C2559 VIN.t192 VSS 0.0266f ; **FLOATING
C2560 VIN.t191 VSS 0.0266f ; **FLOATING
C2561 VIN.n1385 VSS 0.2307f ; **FLOATING
C2562 VIN.n1386 VSS 0.10145f ; **FLOATING
C2563 VIN.t163 VSS 0.0266f ; **FLOATING
C2564 VIN.t162 VSS 0.0266f ; **FLOATING
C2565 VIN.n1387 VSS 0.2307f ; **FLOATING
C2566 VIN.n1388 VSS 0.08815f ; **FLOATING
C2567 VIN.t161 VSS 0.0266f ; **FLOATING
C2568 VIN.t160 VSS 0.0266f ; **FLOATING
C2569 VIN.n1389 VSS 0.2307f ; **FLOATING
C2570 VIN.n1390 VSS 0.11237f ; **FLOATING
C2571 VIN.t219 VSS 0.0266f ; **FLOATING
C2572 VIN.t218 VSS 0.0266f ; **FLOATING
C2573 VIN.n1391 VSS 0.2307f ; **FLOATING
C2574 VIN.n1392 VSS 0.09733f ; **FLOATING
C2575 VIN.t217 VSS 0.0266f ; **FLOATING
C2576 VIN.t216 VSS 0.0266f ; **FLOATING
C2577 VIN.n1393 VSS 0.2307f ; **FLOATING
C2578 VIN.n1394 VSS 0.09226f ; **FLOATING
C2579 VIN.t157 VSS 0.0266f ; **FLOATING
C2580 VIN.t156 VSS 0.0266f ; **FLOATING
C2581 VIN.n1395 VSS 0.2307f ; **FLOATING
C2582 VIN.n1396 VSS 0.11237f ; **FLOATING
C2583 VIN.t155 VSS 0.0266f ; **FLOATING
C2584 VIN.t154 VSS 0.0266f ; **FLOATING
C2585 VIN.n1397 VSS 0.2307f ; **FLOATING
C2586 VIN.n1398 VSS 0.09321f ; **FLOATING
C2587 VIN.t149 VSS 0.0266f ; **FLOATING
C2588 VIN.t148 VSS 0.0266f ; **FLOATING
C2589 VIN.n1399 VSS 0.2307f ; **FLOATING
C2590 VIN.n1400 VSS 0.09638f ; **FLOATING
C2591 VIN.t147 VSS 0.0266f ; **FLOATING
C2592 VIN.t146 VSS 0.0266f ; **FLOATING
C2593 VIN.n1401 VSS 0.2307f ; **FLOATING
C2594 VIN.n1402 VSS 0.21731f ; **FLOATING
C2595 VIN.t153 VSS 0.2717f ; **FLOATING
C2596 VIN.n1403 VSS 0.07632f ; **FLOATING
C2597 VIN.n1404 VSS 1.06045f ; **FLOATING
C2598 VIN.n1405 VSS 1.58945f ; **FLOATING
C2599 VIN.n1406 VSS 0.07632f ; **FLOATING
C2600 VIN.t145 VSS 0.0266f ; **FLOATING
C2601 VIN.t143 VSS 0.0266f ; **FLOATING
C2602 VIN.n1407 VSS 0.2307f ; **FLOATING
C2603 VIN.n1408 VSS 0.11237f ; **FLOATING
C2604 VIN.t141 VSS 0.0266f ; **FLOATING
C2605 VIN.t140 VSS 0.0266f ; **FLOATING
C2606 VIN.n1409 VSS 0.2307f ; **FLOATING
C2607 VIN.n1410 VSS 0.10556f ; **FLOATING
C2608 VIN.t238 VSS 0.0266f ; **FLOATING
C2609 VIN.t237 VSS 0.0266f ; **FLOATING
C2610 VIN.n1411 VSS 0.2307f ; **FLOATING
C2611 VIN.n1412 VSS 0.08403f ; **FLOATING
C2612 VIN.t236 VSS 0.0266f ; **FLOATING
C2613 VIN.t235 VSS 0.0266f ; **FLOATING
C2614 VIN.n1413 VSS 0.2307f ; **FLOATING
C2615 VIN.n1414 VSS 0.11237f ; **FLOATING
C2616 VIN.t279 VSS 0.0266f ; **FLOATING
C2617 VIN.t278 VSS 0.0266f ; **FLOATING
C2618 VIN.n1415 VSS 0.2307f ; **FLOATING
C2619 VIN.n1416 VSS 0.10145f ; **FLOATING
C2620 VIN.t277 VSS 0.0266f ; **FLOATING
C2621 VIN.t276 VSS 0.0266f ; **FLOATING
C2622 VIN.n1417 VSS 0.2307f ; **FLOATING
C2623 VIN.n1418 VSS 0.08815f ; **FLOATING
C2624 VIN.t139 VSS 0.0266f ; **FLOATING
C2625 VIN.t138 VSS 0.0266f ; **FLOATING
C2626 VIN.n1419 VSS 0.2307f ; **FLOATING
C2627 VIN.n1420 VSS 0.11237f ; **FLOATING
C2628 VIN.t251 VSS 0.0266f ; **FLOATING
C2629 VIN.t56 VSS 0.0266f ; **FLOATING
C2630 VIN.n1421 VSS 0.2307f ; **FLOATING
C2631 VIN.n1422 VSS 0.09733f ; **FLOATING
C2632 VIN.t7 VSS 0.0266f ; **FLOATING
C2633 VIN.t59 VSS 0.0266f ; **FLOATING
C2634 VIN.n1423 VSS 0.2307f ; **FLOATING
C2635 VIN.n1424 VSS 0.09226f ; **FLOATING
C2636 VIN.t211 VSS 0.0266f ; **FLOATING
C2637 VIN.t67 VSS 0.0266f ; **FLOATING
C2638 VIN.n1425 VSS 0.2307f ; **FLOATING
C2639 VIN.n1426 VSS 0.11237f ; **FLOATING
C2640 VIN.t14 VSS 0.0266f ; **FLOATING
C2641 VIN.t40 VSS 0.0266f ; **FLOATING
C2642 VIN.n1427 VSS 0.2307f ; **FLOATING
C2643 VIN.n1428 VSS 0.09321f ; **FLOATING
C2644 VIN.t159 VSS 0.0266f ; **FLOATING
C2645 VIN.t66 VSS 0.0266f ; **FLOATING
C2646 VIN.n1429 VSS 0.2307f ; **FLOATING
C2647 VIN.n1430 VSS 0.09638f ; **FLOATING
C2648 VIN.t38 VSS 0.0266f ; **FLOATING
C2649 VIN.t49 VSS 0.0266f ; **FLOATING
C2650 VIN.n1431 VSS 0.2307f ; **FLOATING
C2651 VIN.n1432 VSS 0.21731f ; **FLOATING
C2652 VIN.t220 VSS 0.2717f ; **FLOATING
C2653 VIN.n1433 VSS 0.28356f ; **FLOATING
C2654 VIN.t221 VSS 0.0266f ; **FLOATING
C2655 VIN.t248 VSS 0.0266f ; **FLOATING
C2656 VIN.n1434 VSS 0.2307f ; **FLOATING
C2657 VIN.n1435 VSS 0.11237f ; **FLOATING
C2658 VIN.t19 VSS 0.0266f ; **FLOATING
C2659 VIN.t31 VSS 0.0266f ; **FLOATING
C2660 VIN.n1436 VSS 0.2307f ; **FLOATING
C2661 VIN.n1437 VSS 0.10556f ; **FLOATING
C2662 VIN.t165 VSS 0.0266f ; **FLOATING
C2663 VIN.t27 VSS 0.0266f ; **FLOATING
C2664 VIN.n1438 VSS 0.2307f ; **FLOATING
C2665 VIN.n1439 VSS 0.08403f ; **FLOATING
C2666 VIN.t44 VSS 0.0266f ; **FLOATING
C2667 VIN.t260 VSS 0.0266f ; **FLOATING
C2668 VIN.n1440 VSS 0.2307f ; **FLOATING
C2669 VIN.n1441 VSS 0.11237f ; **FLOATING
C2670 VIN.t164 VSS 0.0266f ; **FLOATING
C2671 VIN.t5 VSS 0.0266f ; **FLOATING
C2672 VIN.n1442 VSS 0.2307f ; **FLOATING
C2673 VIN.n1443 VSS 0.10145f ; **FLOATING
C2674 VIN.t42 VSS 0.0266f ; **FLOATING
C2675 VIN.t158 VSS 0.0266f ; **FLOATING
C2676 VIN.n1444 VSS 0.2307f ; **FLOATING
C2677 VIN.n1445 VSS 0.08815f ; **FLOATING
C2678 VIN.t47 VSS 0.0266f ; **FLOATING
C2679 VIN.t58 VSS 0.0266f ; **FLOATING
C2680 VIN.n1446 VSS 0.2307f ; **FLOATING
C2681 VIN.n1447 VSS 0.11237f ; **FLOATING
C2682 VIN.t12 VSS 0.0266f ; **FLOATING
C2683 VIN.t37 VSS 0.0266f ; **FLOATING
C2684 VIN.n1448 VSS 0.2307f ; **FLOATING
C2685 VIN.n1449 VSS 0.09733f ; **FLOATING
C2686 VIN.t170 VSS 0.0266f ; **FLOATING
C2687 VIN.t35 VSS 0.0266f ; **FLOATING
C2688 VIN.n1450 VSS 0.2307f ; **FLOATING
C2689 VIN.n1451 VSS 0.09226f ; **FLOATING
C2690 VIN.t21 VSS 0.0266f ; **FLOATING
C2691 VIN.t1 VSS 0.0266f ; **FLOATING
C2692 VIN.n1452 VSS 0.2307f ; **FLOATING
C2693 VIN.n1453 VSS 0.11237f ; **FLOATING
C2694 VIN.t73 VSS 0.0266f ; **FLOATING
C2695 VIN.t74 VSS 0.0266f ; **FLOATING
C2696 VIN.n1454 VSS 0.2307f ; **FLOATING
C2697 VIN.n1455 VSS 0.09321f ; **FLOATING
C2698 VIN.t23 VSS 0.0266f ; **FLOATING
C2699 VIN.t104 VSS 0.0266f ; **FLOATING
C2700 VIN.n1456 VSS 0.2307f ; **FLOATING
C2701 VIN.n1457 VSS 0.09638f ; **FLOATING
C2702 VIN.t9 VSS 0.0266f ; **FLOATING
C2703 VIN.t247 VSS 0.0266f ; **FLOATING
C2704 VIN.n1458 VSS 0.2307f ; **FLOATING
C2705 VIN.n1459 VSS 0.21731f ; **FLOATING
C2706 VIN.t17 VSS 0.2717f ; **FLOATING
C2707 VIN.n1460 VSS 0.13929f ; **FLOATING
C2708 VOUT.t20 VSS 1.40897f ; **FLOATING
C2709 VOUT.n0 VSS 9.28746f ; **FLOATING
C2710 VOUT.t203 VSS 19.8423f ; **FLOATING
C2711 VOUT.n1 VSS 20.7431f ; **FLOATING
C2712 VOUT.t202 VSS 5.4745f ; **FLOATING
C2713 VOUT.n2 VSS 6.86363f ; **FLOATING
C2714 VOUT.n3 VSS 11.3938f ; **FLOATING
C2715 VOUT.n4 VSS 8.17078f ; **FLOATING
C2716 VOUT.n5 VSS 8.17078f ; **FLOATING
C2717 VOUT.n6 VSS 18.0444f ; **FLOATING
C2718 VOUT.n7 VSS 5.13652f ; **FLOATING
C2719 VOUT.n8 VSS 1.95957f ; **FLOATING
C2720 VOUT.n9 VSS 1.95957f ; **FLOATING
C2721 VOUT.n10 VSS 1.95957f ; **FLOATING
C2722 VOUT.n11 VSS 1.95957f ; **FLOATING
C2723 VOUT.n12 VSS 2.9371f ; **FLOATING
C2724 VOUT.t1 VSS 0.04915f ; **FLOATING
C2725 VOUT.t12 VSS 0.04915f ; **FLOATING
C2726 VOUT.n13 VSS 0.46006f ; **FLOATING
C2727 VOUT.n14 VSS 0.37438f ; **FLOATING
C2728 VOUT.t205 VSS 0.04915f ; **FLOATING
C2729 VOUT.t164 VSS 0.04915f ; **FLOATING
C2730 VOUT.n15 VSS 0.46006f ; **FLOATING
C2731 VOUT.n16 VSS 0.20819f ; **FLOATING
C2732 VOUT.t191 VSS 0.04915f ; **FLOATING
C2733 VOUT.t8 VSS 0.04915f ; **FLOATING
C2734 VOUT.n17 VSS 0.46006f ; **FLOATING
C2735 VOUT.n18 VSS 0.16079f ; **FLOATING
C2736 VOUT.n19 VSS 0.25739f ; **FLOATING
C2737 VOUT.n20 VSS 0.25739f ; **FLOATING
C2738 VOUT.n21 VSS 0.25739f ; **FLOATING
C2739 VOUT.n22 VSS 0.25739f ; **FLOATING
C2740 VOUT.n23 VSS 0.54389f ; **FLOATING
C2741 VOUT.n24 VSS 0.3739f ; **FLOATING
C2742 VOUT.n25 VSS 0.3739f ; **FLOATING
C2743 VOUT.n26 VSS 0.3739f ; **FLOATING
C2744 VOUT.t99 VSS 0.04915f ; **FLOATING
C2745 VOUT.t98 VSS 0.04915f ; **FLOATING
C2746 VOUT.n27 VSS 0.46006f ; **FLOATING
C2747 VOUT.n28 VSS 0.33694f ; **FLOATING
C2748 VOUT.t97 VSS 0.04915f ; **FLOATING
C2749 VOUT.t92 VSS 0.04915f ; **FLOATING
C2750 VOUT.n29 VSS 0.46006f ; **FLOATING
C2751 VOUT.n30 VSS 0.20819f ; **FLOATING
C2752 VOUT.t91 VSS 0.04915f ; **FLOATING
C2753 VOUT.t90 VSS 0.04915f ; **FLOATING
C2754 VOUT.n31 VSS 0.46006f ; **FLOATING
C2755 VOUT.n32 VSS 0.16079f ; **FLOATING
C2756 VOUT.n33 VSS 0.14102f ; **FLOATING
C2757 VOUT.n34 VSS 0.14102f ; **FLOATING
C2758 VOUT.n35 VSS 0.14102f ; **FLOATING
C2759 VOUT.n36 VSS 0.14102f ; **FLOATING
C2760 VOUT.n37 VSS 4.61338f ; **FLOATING
C2761 VOUT.n38 VSS 1.95957f ; **FLOATING
C2762 VOUT.n39 VSS 1.95957f ; **FLOATING
C2763 VOUT.n40 VSS 1.95957f ; **FLOATING
C2764 VOUT.t122 VSS 0.04915f ; **FLOATING
C2765 VOUT.t129 VSS 0.04915f ; **FLOATING
C2766 VOUT.n41 VSS 0.46006f ; **FLOATING
C2767 VOUT.n42 VSS 0.33694f ; **FLOATING
C2768 VOUT.t128 VSS 0.04915f ; **FLOATING
C2769 VOUT.t127 VSS 0.04915f ; **FLOATING
C2770 VOUT.n43 VSS 0.46006f ; **FLOATING
C2771 VOUT.n44 VSS 0.20819f ; **FLOATING
C2772 VOUT.t126 VSS 0.04915f ; **FLOATING
C2773 VOUT.t145 VSS 0.04915f ; **FLOATING
C2774 VOUT.n45 VSS 0.46006f ; **FLOATING
C2775 VOUT.n46 VSS 0.16079f ; **FLOATING
C2776 VOUT.n47 VSS 0.14102f ; **FLOATING
C2777 VOUT.n48 VSS 0.14102f ; **FLOATING
C2778 VOUT.n49 VSS 0.14102f ; **FLOATING
C2779 VOUT.n50 VSS 4.61338f ; **FLOATING
C2780 VOUT.n51 VSS 1.95957f ; **FLOATING
C2781 VOUT.n52 VSS 1.95957f ; **FLOATING
C2782 VOUT.t38 VSS 0.04915f ; **FLOATING
C2783 VOUT.t37 VSS 0.04915f ; **FLOATING
C2784 VOUT.n53 VSS 0.46006f ; **FLOATING
C2785 VOUT.n54 VSS 0.33694f ; **FLOATING
C2786 VOUT.t36 VSS 0.04915f ; **FLOATING
C2787 VOUT.t149 VSS 0.04915f ; **FLOATING
C2788 VOUT.n55 VSS 0.46006f ; **FLOATING
C2789 VOUT.n56 VSS 0.20819f ; **FLOATING
C2790 VOUT.t148 VSS 0.04915f ; **FLOATING
C2791 VOUT.t147 VSS 0.04915f ; **FLOATING
C2792 VOUT.n57 VSS 0.46006f ; **FLOATING
C2793 VOUT.n58 VSS 0.16079f ; **FLOATING
C2794 VOUT.n59 VSS 0.14102f ; **FLOATING
C2795 VOUT.n60 VSS 0.14102f ; **FLOATING
C2796 VOUT.n61 VSS 4.61338f ; **FLOATING
C2797 VOUT.n62 VSS 1.95957f ; **FLOATING
C2798 VOUT.t54 VSS 0.04915f ; **FLOATING
C2799 VOUT.t173 VSS 0.04915f ; **FLOATING
C2800 VOUT.n63 VSS 0.46006f ; **FLOATING
C2801 VOUT.n64 VSS 0.33694f ; **FLOATING
C2802 VOUT.t172 VSS 0.04915f ; **FLOATING
C2803 VOUT.t171 VSS 0.04915f ; **FLOATING
C2804 VOUT.n65 VSS 0.46006f ; **FLOATING
C2805 VOUT.n66 VSS 0.20819f ; **FLOATING
C2806 VOUT.t170 VSS 0.04915f ; **FLOATING
C2807 VOUT.t200 VSS 0.04915f ; **FLOATING
C2808 VOUT.n67 VSS 0.46006f ; **FLOATING
C2809 VOUT.n68 VSS 0.16079f ; **FLOATING
C2810 VOUT.n69 VSS 0.14102f ; **FLOATING
C2811 VOUT.t165 VSS 0.04915f ; **FLOATING
C2812 VOUT.t169 VSS 0.04915f ; **FLOATING
C2813 VOUT.n70 VSS 0.46006f ; **FLOATING
C2814 VOUT.n71 VSS 0.37438f ; **FLOATING
C2815 VOUT.t168 VSS 0.04915f ; **FLOATING
C2816 VOUT.t167 VSS 0.04915f ; **FLOATING
C2817 VOUT.n72 VSS 0.46006f ; **FLOATING
C2818 VOUT.n73 VSS 0.20819f ; **FLOATING
C2819 VOUT.t166 VSS 0.04915f ; **FLOATING
C2820 VOUT.t86 VSS 0.04915f ; **FLOATING
C2821 VOUT.n74 VSS 0.46006f ; **FLOATING
C2822 VOUT.n75 VSS 0.16079f ; **FLOATING
C2823 VOUT.n76 VSS 0.14102f ; **FLOATING
C2824 VOUT.n77 VSS 0.14102f ; **FLOATING
C2825 VOUT.n78 VSS 0.14102f ; **FLOATING
C2826 VOUT.n79 VSS 0.33908f ; **FLOATING
C2827 VOUT.t85 VSS 0.04915f ; **FLOATING
C2828 VOUT.t84 VSS 0.04915f ; **FLOATING
C2829 VOUT.n80 VSS 0.46006f ; **FLOATING
C2830 VOUT.n81 VSS 0.21697f ; **FLOATING
C2831 VOUT.t83 VSS 0.04915f ; **FLOATING
C2832 VOUT.t196 VSS 0.04915f ; **FLOATING
C2833 VOUT.n82 VSS 0.46006f ; **FLOATING
C2834 VOUT.n83 VSS 0.20059f ; **FLOATING
C2835 VOUT.t195 VSS 0.04915f ; **FLOATING
C2836 VOUT.t194 VSS 0.04915f ; **FLOATING
C2837 VOUT.n84 VSS 0.46006f ; **FLOATING
C2838 VOUT.n85 VSS 0.1684f ; **FLOATING
C2839 VOUT.t193 VSS 0.04915f ; **FLOATING
C2840 VOUT.t78 VSS 0.04915f ; **FLOATING
C2841 VOUT.n86 VSS 0.46006f ; **FLOATING
C2842 VOUT.n87 VSS 0.21697f ; **FLOATING
C2843 VOUT.t77 VSS 0.04915f ; **FLOATING
C2844 VOUT.t76 VSS 0.04915f ; **FLOATING
C2845 VOUT.n88 VSS 0.46006f ; **FLOATING
C2846 VOUT.n89 VSS 0.19298f ; **FLOATING
C2847 VOUT.t75 VSS 0.04915f ; **FLOATING
C2848 VOUT.t61 VSS 0.04915f ; **FLOATING
C2849 VOUT.n90 VSS 0.46006f ; **FLOATING
C2850 VOUT.n91 VSS 0.17601f ; **FLOATING
C2851 VOUT.t60 VSS 0.04915f ; **FLOATING
C2852 VOUT.t59 VSS 0.04915f ; **FLOATING
C2853 VOUT.n92 VSS 0.46006f ; **FLOATING
C2854 VOUT.n93 VSS 0.21697f ; **FLOATING
C2855 VOUT.t58 VSS 0.04915f ; **FLOATING
C2856 VOUT.t177 VSS 0.04915f ; **FLOATING
C2857 VOUT.n94 VSS 0.46006f ; **FLOATING
C2858 VOUT.n95 VSS 0.18537f ; **FLOATING
C2859 VOUT.t176 VSS 0.04915f ; **FLOATING
C2860 VOUT.t175 VSS 0.04915f ; **FLOATING
C2861 VOUT.n96 VSS 0.46006f ; **FLOATING
C2862 VOUT.n97 VSS 0.18362f ; **FLOATING
C2863 VOUT.t174 VSS 0.04915f ; **FLOATING
C2864 VOUT.t53 VSS 0.04915f ; **FLOATING
C2865 VOUT.n98 VSS 0.46006f ; **FLOATING
C2866 VOUT.n99 VSS 0.21697f ; **FLOATING
C2867 VOUT.t52 VSS 0.04915f ; **FLOATING
C2868 VOUT.t51 VSS 0.04915f ; **FLOATING
C2869 VOUT.n100 VSS 0.46006f ; **FLOATING
C2870 VOUT.n101 VSS 0.17776f ; **FLOATING
C2871 VOUT.t50 VSS 0.04915f ; **FLOATING
C2872 VOUT.t45 VSS 0.04915f ; **FLOATING
C2873 VOUT.n102 VSS 0.46786f ; **FLOATING
C2874 VOUT.n103 VSS 0.14102f ; **FLOATING
C2875 VOUT.n104 VSS 4.61338f ; **FLOATING
C2876 VOUT.t44 VSS 0.04915f ; **FLOATING
C2877 VOUT.t43 VSS 0.04915f ; **FLOATING
C2878 VOUT.n105 VSS 0.46006f ; **FLOATING
C2879 VOUT.n106 VSS 0.33694f ; **FLOATING
C2880 VOUT.t42 VSS 0.04915f ; **FLOATING
C2881 VOUT.t185 VSS 0.04915f ; **FLOATING
C2882 VOUT.n107 VSS 0.46006f ; **FLOATING
C2883 VOUT.n108 VSS 0.20819f ; **FLOATING
C2884 VOUT.t184 VSS 0.04915f ; **FLOATING
C2885 VOUT.t183 VSS 0.04915f ; **FLOATING
C2886 VOUT.n109 VSS 0.46006f ; **FLOATING
C2887 VOUT.n110 VSS 0.16079f ; **FLOATING
C2888 VOUT.n111 VSS 0.14102f ; **FLOATING
C2889 VOUT.n112 VSS 0.14102f ; **FLOATING
C2890 VOUT.n113 VSS 0.14102f ; **FLOATING
C2891 VOUT.n114 VSS 0.33908f ; **FLOATING
C2892 VOUT.t182 VSS 0.04915f ; **FLOATING
C2893 VOUT.t82 VSS 0.04915f ; **FLOATING
C2894 VOUT.n115 VSS 0.46006f ; **FLOATING
C2895 VOUT.n116 VSS 0.21697f ; **FLOATING
C2896 VOUT.t81 VSS 0.04915f ; **FLOATING
C2897 VOUT.t80 VSS 0.04915f ; **FLOATING
C2898 VOUT.n117 VSS 0.46006f ; **FLOATING
C2899 VOUT.n118 VSS 0.20059f ; **FLOATING
C2900 VOUT.t79 VSS 0.04915f ; **FLOATING
C2901 VOUT.t65 VSS 0.04915f ; **FLOATING
C2902 VOUT.n119 VSS 0.46006f ; **FLOATING
C2903 VOUT.n120 VSS 0.1684f ; **FLOATING
C2904 VOUT.t64 VSS 0.04915f ; **FLOATING
C2905 VOUT.t63 VSS 0.04915f ; **FLOATING
C2906 VOUT.n121 VSS 0.46006f ; **FLOATING
C2907 VOUT.n122 VSS 0.21697f ; **FLOATING
C2908 VOUT.t62 VSS 0.04915f ; **FLOATING
C2909 VOUT.t189 VSS 0.04915f ; **FLOATING
C2910 VOUT.n123 VSS 0.46006f ; **FLOATING
C2911 VOUT.n124 VSS 0.19298f ; **FLOATING
C2912 VOUT.t188 VSS 0.04915f ; **FLOATING
C2913 VOUT.t187 VSS 0.04915f ; **FLOATING
C2914 VOUT.n125 VSS 0.46006f ; **FLOATING
C2915 VOUT.n126 VSS 0.17601f ; **FLOATING
C2916 VOUT.t186 VSS 0.04915f ; **FLOATING
C2917 VOUT.t74 VSS 0.04915f ; **FLOATING
C2918 VOUT.n127 VSS 0.46006f ; **FLOATING
C2919 VOUT.n128 VSS 0.21697f ; **FLOATING
C2920 VOUT.t73 VSS 0.04915f ; **FLOATING
C2921 VOUT.t72 VSS 0.04915f ; **FLOATING
C2922 VOUT.n129 VSS 0.46006f ; **FLOATING
C2923 VOUT.n130 VSS 0.18537f ; **FLOATING
C2924 VOUT.t71 VSS 0.04915f ; **FLOATING
C2925 VOUT.t49 VSS 0.04915f ; **FLOATING
C2926 VOUT.n131 VSS 0.46006f ; **FLOATING
C2927 VOUT.n132 VSS 0.18362f ; **FLOATING
C2928 VOUT.t48 VSS 0.04915f ; **FLOATING
C2929 VOUT.t47 VSS 0.04915f ; **FLOATING
C2930 VOUT.n133 VSS 0.46006f ; **FLOATING
C2931 VOUT.n134 VSS 0.21697f ; **FLOATING
C2932 VOUT.t46 VSS 0.04915f ; **FLOATING
C2933 VOUT.t57 VSS 0.04915f ; **FLOATING
C2934 VOUT.n135 VSS 0.46006f ; **FLOATING
C2935 VOUT.n136 VSS 0.17776f ; **FLOATING
C2936 VOUT.t56 VSS 0.04915f ; **FLOATING
C2937 VOUT.t55 VSS 0.04915f ; **FLOATING
C2938 VOUT.n137 VSS 0.46786f ; **FLOATING
C2939 VOUT.n138 VSS 0.14102f ; **FLOATING
C2940 VOUT.n139 VSS 1.95957f ; **FLOATING
C2941 VOUT.n140 VSS 1.95957f ; **FLOATING
C2942 VOUT.n141 VSS 1.95957f ; **FLOATING
C2943 VOUT.n142 VSS 2.9371f ; **FLOATING
C2944 VOUT.n143 VSS 1.95957f ; **FLOATING
C2945 VOUT.n144 VSS 0.14102f ; **FLOATING
C2946 VOUT.n145 VSS 0.14102f ; **FLOATING
C2947 VOUT.n146 VSS 0.33908f ; **FLOATING
C2948 VOUT.t199 VSS 0.04915f ; **FLOATING
C2949 VOUT.t198 VSS 0.04915f ; **FLOATING
C2950 VOUT.n147 VSS 0.46006f ; **FLOATING
C2951 VOUT.n148 VSS 0.21697f ; **FLOATING
C2952 VOUT.t197 VSS 0.04915f ; **FLOATING
C2953 VOUT.t26 VSS 0.04915f ; **FLOATING
C2954 VOUT.n149 VSS 0.46006f ; **FLOATING
C2955 VOUT.n150 VSS 0.20059f ; **FLOATING
C2956 VOUT.t25 VSS 0.04915f ; **FLOATING
C2957 VOUT.t24 VSS 0.04915f ; **FLOATING
C2958 VOUT.n151 VSS 0.46006f ; **FLOATING
C2959 VOUT.n152 VSS 0.1684f ; **FLOATING
C2960 VOUT.t23 VSS 0.04915f ; **FLOATING
C2961 VOUT.t33 VSS 0.04915f ; **FLOATING
C2962 VOUT.n153 VSS 0.46006f ; **FLOATING
C2963 VOUT.n154 VSS 0.21697f ; **FLOATING
C2964 VOUT.t32 VSS 0.04915f ; **FLOATING
C2965 VOUT.t31 VSS 0.04915f ; **FLOATING
C2966 VOUT.n155 VSS 0.46006f ; **FLOATING
C2967 VOUT.n156 VSS 0.19298f ; **FLOATING
C2968 VOUT.t30 VSS 0.04915f ; **FLOATING
C2969 VOUT.t209 VSS 0.04915f ; **FLOATING
C2970 VOUT.n157 VSS 0.46006f ; **FLOATING
C2971 VOUT.n158 VSS 0.17601f ; **FLOATING
C2972 VOUT.t208 VSS 0.04915f ; **FLOATING
C2973 VOUT.t207 VSS 0.04915f ; **FLOATING
C2974 VOUT.n159 VSS 0.46006f ; **FLOATING
C2975 VOUT.n160 VSS 0.21697f ; **FLOATING
C2976 VOUT.t206 VSS 0.04915f ; **FLOATING
C2977 VOUT.t116 VSS 0.04915f ; **FLOATING
C2978 VOUT.n161 VSS 0.46006f ; **FLOATING
C2979 VOUT.n162 VSS 0.18537f ; **FLOATING
C2980 VOUT.t115 VSS 0.04915f ; **FLOATING
C2981 VOUT.t114 VSS 0.04915f ; **FLOATING
C2982 VOUT.n163 VSS 0.46006f ; **FLOATING
C2983 VOUT.n164 VSS 0.18362f ; **FLOATING
C2984 VOUT.t113 VSS 0.04915f ; **FLOATING
C2985 VOUT.t69 VSS 0.04915f ; **FLOATING
C2986 VOUT.n165 VSS 0.46006f ; **FLOATING
C2987 VOUT.n166 VSS 0.21697f ; **FLOATING
C2988 VOUT.t68 VSS 0.04915f ; **FLOATING
C2989 VOUT.t67 VSS 0.04915f ; **FLOATING
C2990 VOUT.n167 VSS 0.46006f ; **FLOATING
C2991 VOUT.n168 VSS 0.17776f ; **FLOATING
C2992 VOUT.t66 VSS 0.04915f ; **FLOATING
C2993 VOUT.t39 VSS 0.04915f ; **FLOATING
C2994 VOUT.n169 VSS 0.46786f ; **FLOATING
C2995 VOUT.n170 VSS 0.14102f ; **FLOATING
C2996 VOUT.n171 VSS 1.95957f ; **FLOATING
C2997 VOUT.n172 VSS 1.95957f ; **FLOATING
C2998 VOUT.n173 VSS 2.9371f ; **FLOATING
C2999 VOUT.n174 VSS 1.95957f ; **FLOATING
C3000 VOUT.n175 VSS 0.14102f ; **FLOATING
C3001 VOUT.n176 VSS 0.33908f ; **FLOATING
C3002 VOUT.t146 VSS 0.04915f ; **FLOATING
C3003 VOUT.t141 VSS 0.04915f ; **FLOATING
C3004 VOUT.n177 VSS 0.46006f ; **FLOATING
C3005 VOUT.n178 VSS 0.21697f ; **FLOATING
C3006 VOUT.t140 VSS 0.04915f ; **FLOATING
C3007 VOUT.t139 VSS 0.04915f ; **FLOATING
C3008 VOUT.n179 VSS 0.46006f ; **FLOATING
C3009 VOUT.n180 VSS 0.20059f ; **FLOATING
C3010 VOUT.t138 VSS 0.04915f ; **FLOATING
C3011 VOUT.t153 VSS 0.04915f ; **FLOATING
C3012 VOUT.n181 VSS 0.46006f ; **FLOATING
C3013 VOUT.n182 VSS 0.1684f ; **FLOATING
C3014 VOUT.t152 VSS 0.04915f ; **FLOATING
C3015 VOUT.t151 VSS 0.04915f ; **FLOATING
C3016 VOUT.n183 VSS 0.46006f ; **FLOATING
C3017 VOUT.n184 VSS 0.21697f ; **FLOATING
C3018 VOUT.t150 VSS 0.04915f ; **FLOATING
C3019 VOUT.t121 VSS 0.04915f ; **FLOATING
C3020 VOUT.n185 VSS 0.46006f ; **FLOATING
C3021 VOUT.n186 VSS 0.19298f ; **FLOATING
C3022 VOUT.t120 VSS 0.04915f ; **FLOATING
C3023 VOUT.t119 VSS 0.04915f ; **FLOATING
C3024 VOUT.n187 VSS 0.46006f ; **FLOATING
C3025 VOUT.n188 VSS 0.17601f ; **FLOATING
C3026 VOUT.t118 VSS 0.04915f ; **FLOATING
C3027 VOUT.t158 VSS 0.04915f ; **FLOATING
C3028 VOUT.n189 VSS 0.46006f ; **FLOATING
C3029 VOUT.n190 VSS 0.21697f ; **FLOATING
C3030 VOUT.t157 VSS 0.04915f ; **FLOATING
C3031 VOUT.t156 VSS 0.04915f ; **FLOATING
C3032 VOUT.n191 VSS 0.46006f ; **FLOATING
C3033 VOUT.n192 VSS 0.18537f ; **FLOATING
C3034 VOUT.t155 VSS 0.04915f ; **FLOATING
C3035 VOUT.t133 VSS 0.04915f ; **FLOATING
C3036 VOUT.n193 VSS 0.46006f ; **FLOATING
C3037 VOUT.n194 VSS 0.18362f ; **FLOATING
C3038 VOUT.t132 VSS 0.04915f ; **FLOATING
C3039 VOUT.t131 VSS 0.04915f ; **FLOATING
C3040 VOUT.n195 VSS 0.46006f ; **FLOATING
C3041 VOUT.n196 VSS 0.21697f ; **FLOATING
C3042 VOUT.t130 VSS 0.04915f ; **FLOATING
C3043 VOUT.t125 VSS 0.04915f ; **FLOATING
C3044 VOUT.n197 VSS 0.46006f ; **FLOATING
C3045 VOUT.n198 VSS 0.17776f ; **FLOATING
C3046 VOUT.t124 VSS 0.04915f ; **FLOATING
C3047 VOUT.t123 VSS 0.04915f ; **FLOATING
C3048 VOUT.n199 VSS 0.46786f ; **FLOATING
C3049 VOUT.n200 VSS 0.14102f ; **FLOATING
C3050 VOUT.n201 VSS 1.95957f ; **FLOATING
C3051 VOUT.n202 VSS 2.9371f ; **FLOATING
C3052 VOUT.n203 VSS 1.95957f ; **FLOATING
C3053 VOUT.n204 VSS 0.33908f ; **FLOATING
C3054 VOUT.t144 VSS 0.04915f ; **FLOATING
C3055 VOUT.t143 VSS 0.04915f ; **FLOATING
C3056 VOUT.n205 VSS 0.46006f ; **FLOATING
C3057 VOUT.n206 VSS 0.21697f ; **FLOATING
C3058 VOUT.t142 VSS 0.04915f ; **FLOATING
C3059 VOUT.t137 VSS 0.04915f ; **FLOATING
C3060 VOUT.n207 VSS 0.46006f ; **FLOATING
C3061 VOUT.n208 VSS 0.20059f ; **FLOATING
C3062 VOUT.t136 VSS 0.04915f ; **FLOATING
C3063 VOUT.t135 VSS 0.04915f ; **FLOATING
C3064 VOUT.n209 VSS 0.46006f ; **FLOATING
C3065 VOUT.n210 VSS 0.1684f ; **FLOATING
C3066 VOUT.t134 VSS 0.04915f ; **FLOATING
C3067 VOUT.t110 VSS 0.04915f ; **FLOATING
C3068 VOUT.n211 VSS 0.46006f ; **FLOATING
C3069 VOUT.n212 VSS 0.21697f ; **FLOATING
C3070 VOUT.t109 VSS 0.04915f ; **FLOATING
C3071 VOUT.t108 VSS 0.04915f ; **FLOATING
C3072 VOUT.n213 VSS 0.46006f ; **FLOATING
C3073 VOUT.n214 VSS 0.19298f ; **FLOATING
C3074 VOUT.t107 VSS 0.04915f ; **FLOATING
C3075 VOUT.t162 VSS 0.04915f ; **FLOATING
C3076 VOUT.n215 VSS 0.46006f ; **FLOATING
C3077 VOUT.n216 VSS 0.17601f ; **FLOATING
C3078 VOUT.t161 VSS 0.04915f ; **FLOATING
C3079 VOUT.t160 VSS 0.04915f ; **FLOATING
C3080 VOUT.n217 VSS 0.46006f ; **FLOATING
C3081 VOUT.n218 VSS 0.21697f ; **FLOATING
C3082 VOUT.t159 VSS 0.04915f ; **FLOATING
C3083 VOUT.t104 VSS 0.04915f ; **FLOATING
C3084 VOUT.n219 VSS 0.46006f ; **FLOATING
C3085 VOUT.n220 VSS 0.18537f ; **FLOATING
C3086 VOUT.t103 VSS 0.04915f ; **FLOATING
C3087 VOUT.t102 VSS 0.04915f ; **FLOATING
C3088 VOUT.n221 VSS 0.46006f ; **FLOATING
C3089 VOUT.n222 VSS 0.18362f ; **FLOATING
C3090 VOUT.t101 VSS 0.04915f ; **FLOATING
C3091 VOUT.t96 VSS 0.04915f ; **FLOATING
C3092 VOUT.n223 VSS 0.46006f ; **FLOATING
C3093 VOUT.n224 VSS 0.21697f ; **FLOATING
C3094 VOUT.t95 VSS 0.04915f ; **FLOATING
C3095 VOUT.t94 VSS 0.04915f ; **FLOATING
C3096 VOUT.n225 VSS 0.46006f ; **FLOATING
C3097 VOUT.n226 VSS 0.17776f ; **FLOATING
C3098 VOUT.t93 VSS 0.04915f ; **FLOATING
C3099 VOUT.t100 VSS 0.04915f ; **FLOATING
C3100 VOUT.n227 VSS 0.46786f ; **FLOATING
C3101 VOUT.n228 VSS 0.14102f ; **FLOATING
C3102 VOUT.n229 VSS 1.95957f ; **FLOATING
C3103 VOUT.n230 VSS 2.9371f ; **FLOATING
C3104 VOUT.n231 VSS 0.33908f ; **FLOATING
C3105 VOUT.t89 VSS 0.04915f ; **FLOATING
C3106 VOUT.t181 VSS 0.04915f ; **FLOATING
C3107 VOUT.n232 VSS 0.46006f ; **FLOATING
C3108 VOUT.n233 VSS 0.21697f ; **FLOATING
C3109 VOUT.t180 VSS 0.04915f ; **FLOATING
C3110 VOUT.t179 VSS 0.04915f ; **FLOATING
C3111 VOUT.n234 VSS 0.46006f ; **FLOATING
C3112 VOUT.n235 VSS 0.20059f ; **FLOATING
C3113 VOUT.t178 VSS 0.04915f ; **FLOATING
C3114 VOUT.t213 VSS 0.04915f ; **FLOATING
C3115 VOUT.n236 VSS 0.46006f ; **FLOATING
C3116 VOUT.n237 VSS 0.1684f ; **FLOATING
C3117 VOUT.t212 VSS 0.04915f ; **FLOATING
C3118 VOUT.t211 VSS 0.04915f ; **FLOATING
C3119 VOUT.n238 VSS 0.46006f ; **FLOATING
C3120 VOUT.n239 VSS 0.21697f ; **FLOATING
C3121 VOUT.t210 VSS 0.04915f ; **FLOATING
C3122 VOUT.t88 VSS 0.04915f ; **FLOATING
C3123 VOUT.n240 VSS 0.46006f ; **FLOATING
C3124 VOUT.n241 VSS 0.19298f ; **FLOATING
C3125 VOUT.t87 VSS 0.04915f ; **FLOATING
C3126 VOUT.t192 VSS 0.04915f ; **FLOATING
C3127 VOUT.n242 VSS 0.46006f ; **FLOATING
C3128 VOUT.n243 VSS 0.17601f ; **FLOATING
C3129 VOUT.t27 VSS 0.04915f ; **FLOATING
C3130 VOUT.t3 VSS 0.04915f ; **FLOATING
C3131 VOUT.n244 VSS 0.46006f ; **FLOATING
C3132 VOUT.n245 VSS 0.21697f ; **FLOATING
C3133 VOUT.t29 VSS 0.04915f ; **FLOATING
C3134 VOUT.t154 VSS 0.04915f ; **FLOATING
C3135 VOUT.n246 VSS 0.46006f ; **FLOATING
C3136 VOUT.n247 VSS 0.18537f ; **FLOATING
C3137 VOUT.t35 VSS 0.04915f ; **FLOATING
C3138 VOUT.t6 VSS 0.04915f ; **FLOATING
C3139 VOUT.n248 VSS 0.46006f ; **FLOATING
C3140 VOUT.n249 VSS 0.18362f ; **FLOATING
C3141 VOUT.t17 VSS 0.04915f ; **FLOATING
C3142 VOUT.t106 VSS 0.04915f ; **FLOATING
C3143 VOUT.n250 VSS 0.46006f ; **FLOATING
C3144 VOUT.n251 VSS 0.21697f ; **FLOATING
C3145 VOUT.t34 VSS 0.04915f ; **FLOATING
C3146 VOUT.t16 VSS 0.04915f ; **FLOATING
C3147 VOUT.n252 VSS 0.46006f ; **FLOATING
C3148 VOUT.n253 VSS 0.17776f ; **FLOATING
C3149 VOUT.t22 VSS 0.04915f ; **FLOATING
C3150 VOUT.t163 VSS 0.04915f ; **FLOATING
C3151 VOUT.n254 VSS 0.46786f ; **FLOATING
C3152 VOUT.n255 VSS 0.54389f ; **FLOATING
C3153 VOUT.t13 VSS 0.04915f ; **FLOATING
C3154 VOUT.t112 VSS 0.04915f ; **FLOATING
C3155 VOUT.n256 VSS 0.46006f ; **FLOATING
C3156 VOUT.n257 VSS 0.21697f ; **FLOATING
C3157 VOUT.t11 VSS 0.04915f ; **FLOATING
C3158 VOUT.t19 VSS 0.04915f ; **FLOATING
C3159 VOUT.n258 VSS 0.46006f ; **FLOATING
C3160 VOUT.n259 VSS 0.20059f ; **FLOATING
C3161 VOUT.t201 VSS 0.04915f ; **FLOATING
C3162 VOUT.t111 VSS 0.04915f ; **FLOATING
C3163 VOUT.n260 VSS 0.46006f ; **FLOATING
C3164 VOUT.n261 VSS 0.1684f ; **FLOATING
C3165 VOUT.t2 VSS 0.04915f ; **FLOATING
C3166 VOUT.t18 VSS 0.04915f ; **FLOATING
C3167 VOUT.n262 VSS 0.46006f ; **FLOATING
C3168 VOUT.n263 VSS 0.21697f ; **FLOATING
C3169 VOUT.t105 VSS 0.04915f ; **FLOATING
C3170 VOUT.t21 VSS 0.04915f ; **FLOATING
C3171 VOUT.n264 VSS 0.46006f ; **FLOATING
C3172 VOUT.n265 VSS 0.19298f ; **FLOATING
C3173 VOUT.t28 VSS 0.04915f ; **FLOATING
C3174 VOUT.t5 VSS 0.04915f ; **FLOATING
C3175 VOUT.n266 VSS 0.46006f ; **FLOATING
C3176 VOUT.n267 VSS 0.17601f ; **FLOATING
C3177 VOUT.t15 VSS 0.04915f ; **FLOATING
C3178 VOUT.t117 VSS 0.04915f ; **FLOATING
C3179 VOUT.n268 VSS 0.46006f ; **FLOATING
C3180 VOUT.n269 VSS 0.21697f ; **FLOATING
C3181 VOUT.t14 VSS 0.04915f ; **FLOATING
C3182 VOUT.t9 VSS 0.04915f ; **FLOATING
C3183 VOUT.n270 VSS 0.46006f ; **FLOATING
C3184 VOUT.n271 VSS 0.18537f ; **FLOATING
C3185 VOUT.t0 VSS 0.04915f ; **FLOATING
C3186 VOUT.t40 VSS 0.04915f ; **FLOATING
C3187 VOUT.n272 VSS 0.46006f ; **FLOATING
C3188 VOUT.n273 VSS 0.18362f ; **FLOATING
C3189 VOUT.t41 VSS 0.04915f ; **FLOATING
C3190 VOUT.t10 VSS 0.04915f ; **FLOATING
C3191 VOUT.n274 VSS 0.46006f ; **FLOATING
C3192 VOUT.n275 VSS 0.21697f ; **FLOATING
C3193 VOUT.t70 VSS 0.04915f ; **FLOATING
C3194 VOUT.t4 VSS 0.04915f ; **FLOATING
C3195 VOUT.n276 VSS 0.46006f ; **FLOATING
C3196 VOUT.n277 VSS 0.17776f ; **FLOATING
C3197 VOUT.t190 VSS 0.04915f ; **FLOATING
C3198 VOUT.t7 VSS 0.04915f ; **FLOATING
C3199 VOUT.n278 VSS 0.46786f ; **FLOATING
C3200 VOUT.n279 VSS 0.45544f ; **FLOATING
C3201 EN.t0 VSS 0.03207f ; **FLOATING
C3202 FB_BUF.n0 VSS 3.55998f ; **FLOATING
C3203 FB_BUF.t0 VSS 0.82572f ; **FLOATING
C3204 FB_BUF.t1 VSS 0.79794f ; **FLOATING
C3205 FB_BUF.n1 VSS 1.57673f ; **FLOATING
C3206 FB_BUF.t2 VSS 2.22749f ; **FLOATING
C3207 EAOUT_BUF.n0 VSS 2.23197f ; **FLOATING
C3208 EAOUT_BUF.t1 VSS 0.57262f ; **FLOATING
C3209 EAOUT_BUF.t2 VSS 0.5475f ; **FLOATING
C3210 EAOUT_BUF.n1 VSS 1.33502f ; **FLOATING
C3211 EAOUT_BUF.t0 VSS 1.32292f ; **FLOATING
C3212 VREF.n0 VSS 1.14251f ; **FLOATING
C3213 VREF.t1 VSS 1.15076f ; **FLOATING
C3214 VREF.t0 VSS 1.16768f ; **FLOATING
.ends
