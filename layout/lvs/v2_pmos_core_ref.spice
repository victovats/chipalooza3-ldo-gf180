.subckt v2_pmos_core EAOUT EAREF ENB_5V EN_5V VIN VIN_BIAS VOUT VREF VSS
XMLOAD1_1 CASCB1 CASCB1 VIN VIN pfet_06v0 w=2.5u l=3.0u
XMLOAD1_2 CASCB1 CASCB1 VIN VIN pfet_06v0 w=2.5u l=3.0u
XMLOAD2_1 CASCB2 CASCB1 VIN VIN pfet_06v0 w=2.5u l=3.0u
XMLOAD2_2 CASCB2 CASCB1 VIN VIN pfet_06v0 w=2.5u l=3.0u
XMLOAD1_3 CASCB1 CASCB1 VIN VIN pfet_06v0 w=2.5u l=3.0u
XMLOAD1_4 CASCB1 CASCB1 VIN VIN pfet_06v0 w=2.5u l=3.0u
XMLOAD2_3 CASCB2 CASCB1 VIN VIN pfet_06v0 w=2.5u l=3.0u
XMLOAD2_4 CASCB2 CASCB1 VIN VIN pfet_06v0 w=2.5u l=3.0u
XMCASC1_1 CASCB1 EAREF EAREF VIN pfet_06v0 w=1.25u l=0.55u
XMCASC1_2 CASCB1 EAREF EAREF VIN pfet_06v0 w=1.25u l=0.55u
XMCASC1_3 CASCB1 EAREF EAREF VIN pfet_06v0 w=1.25u l=0.55u
XMCASC1_4 CASCB1 EAREF EAREF VIN pfet_06v0 w=1.25u l=0.55u
XMCASC2_1 EAOUT EAREF CASCB2 VIN pfet_06v0 w=1.25u l=0.55u
XMCASC2_2 EAOUT EAREF CASCB2 VIN pfet_06v0 w=1.25u l=0.55u
XMCASC2_3 EAOUT EAREF CASCB2 VIN pfet_06v0 w=1.25u l=0.55u
XMCASC2_4 EAOUT EAREF CASCB2 VIN pfet_06v0 w=1.25u l=0.55u
XMENPASSOFF_1 VIN EN_5V EAOUT VIN pfet_06v0 w=5.0u l=0.6u
XMP2_1 EN_5V ENB_5V VIN VIN pfet_06v0 w=5.0u l=0.6u
XMBIASSW_1 VIN_BIAS ENB_5V VIN VIN pfet_06v0 w=5.0u l=0.6u
XMBIASSW_2 VIN_BIAS ENB_5V VIN VIN pfet_06v0 w=5.0u l=0.6u
XMP1_1 ENB_5V VSS VIN VIN pfet_06v0 w=1.0u l=40.0u
.ends
