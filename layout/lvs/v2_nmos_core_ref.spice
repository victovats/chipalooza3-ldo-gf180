.subckt v2_nmos_core EAOUT EAREF EN ENB_5V EN_5V FB IREF VOUT VREF VSS
XMN1_1 ENB_5V EN VSS VSS nfet_06v0 w=0.5u l=5.0u
XMPDREF_1 IREF ENB_5V VSS VSS nfet_05v0 w=1.0u l=0.6u
XMREF_1 IREF IREF VSS VSS nfet_05v0 w=1.25u l=0.6u
XMREF_2 IREF IREF VSS VSS nfet_05v0 w=1.25u l=0.6u
XMREF_3 IREF IREF VSS VSS nfet_05v0 w=1.25u l=0.6u
XMREF_4 IREF IREF VSS VSS nfet_05v0 w=1.25u l=0.6u
XMTAIL_1 TAIL IREF VSS VSS nfet_05v0 w=1.25u l=0.6u
XMTAIL_2 TAIL IREF VSS VSS nfet_05v0 w=1.25u l=0.6u
XMTAIL_3 TAIL IREF VSS VSS nfet_05v0 w=1.25u l=0.6u
XMTAIL_4 TAIL IREF VSS VSS nfet_05v0 w=1.25u l=0.6u
XMENDISCHARGE_1 VOUT ENB_5V VSS VSS nfet_05v0 w=5.0u l=0.6u
XMN2_1 EN_5V ENB_5V VSS VSS nfet_05v0 w=5.0u l=0.6u
XMIN1_1 EAREF FB TAIL VSS nfet_06v0 w=5.0u l=3.0u
XMIN1_2 EAREF FB TAIL VSS nfet_06v0 w=5.0u l=3.0u
XMIN2_1 EAOUT VREF TAIL VSS nfet_06v0 w=5.0u l=3.0u
XMIN2_2 EAOUT VREF TAIL VSS nfet_06v0 w=5.0u l=3.0u
XMIN1_3 EAREF FB TAIL VSS nfet_06v0 w=5.0u l=3.0u
XMIN1_4 EAREF FB TAIL VSS nfet_06v0 w=5.0u l=3.0u
XMIN2_3 EAOUT VREF TAIL VSS nfet_06v0 w=5.0u l=3.0u
XMIN2_4 EAOUT VREF TAIL VSS nfet_06v0 w=5.0u l=3.0u
.ends
