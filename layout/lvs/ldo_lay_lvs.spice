* NGSPICE file created from ldo.ext - technology: gf180mcuD

X0 VIN EAOUT EAOUT_BUF VSS nfet_05v0 ad=3p pd=11.2u as=3p ps=11.2u w=5u l=0.6u
X1 VIN m2_3642_4622# EAOUT VIN pfet_06v0 ad=3p pd=11.2u as=3p ps=11.2u w=5u l=0.6u
X2 m2_28581_4772# m1_19868_3148# VSS VSS nfet_05v0 ad=1.5p pd=6.2u as=1.5p ps=6.2u w=2.5u l=0.6u
X3 m1_19868_3148# m1_19868_3148# VSS VSS nfet_05v0 ad=1.5p pd=6.2u as=1.5p ps=6.2u w=2.5u l=0.6u
X4 m2_28581_4772# m1_19868_3148# VSS VSS nfet_05v0 ad=1.5p pd=6.2u as=1.5p ps=6.2u w=2.5u l=0.6u
X7 m1_19868_3148# m1_19868_3148# VSS VSS nfet_05v0 ad=1.5p pd=6.2u as=1.5p ps=6.2u w=2.5u l=0.6u
X8 VIN EAOUT VOUT VIN pfet_06v0 ad=0.84p pd=3.56u as=0.84p ps=3.56u w=3u l=0.55u
X9 VOUT EAOUT VIN VIN pfet_06v0 ad=0.84p pd=3.56u as=0.84p ps=3.56u w=3u l=0.55u
X10 VIN EAOUT VOUT VIN pfet_06v0 ad=0.84p pd=3.56u as=0.84p ps=3.56u w=3u l=0.55u
X11 VOUT EAOUT VIN VIN pfet_06v0 ad=0.84p pd=3.56u as=0.84p ps=3.56u w=3u l=0.55u
X12 VOUT EAOUT VIN VIN pfet_06v0 ad=0.84p pd=3.56u as=0.84p ps=3.56u w=3u l=0.55u
X13 VOUT EAOUT VIN VIN pfet_06v0 ad=0.84p pd=3.56u as=1.8p ps=7.2u w=3u l=0.55u
X14 VIN EAOUT VOUT VIN pfet_06v0 ad=0.84p pd=3.56u as=0.84p ps=3.56u w=3u l=0.55u
X15 VIN EAOUT VOUT VIN pfet_06v0 ad=1.8p pd=7.2u as=0.84p ps=3.56u w=3u l=0.55u
X16 VOUT EAOUT VIN VIN pfet_06v0 ad=0.84p pd=3.56u as=0.84p ps=3.56u w=3u l=0.55u
X17 VOUT EAOUT VIN VIN pfet_06v0 ad=0.84p pd=3.56u as=0.84p ps=3.56u w=3u l=0.55u
X18 VOUT EAOUT VIN VIN pfet_06v0 ad=0.84p pd=3.56u as=0.84p ps=3.56u w=3u l=0.55u
X19 VOUT EAOUT VIN VIN pfet_06v0 ad=0.84p pd=3.56u as=0.84p ps=3.56u w=3u l=0.55u
X20 VIN EAOUT VOUT VIN pfet_06v0 ad=1.8p pd=7.2u as=0.84p ps=3.56u w=3u l=0.55u
X21 VIN EAOUT VOUT VIN pfet_06v0 ad=0.84p pd=3.56u as=0.84p ps=3.56u w=3u l=0.55u
X22 VOUT EAOUT VIN VIN pfet_06v0 ad=0.84p pd=3.56u as=0.84p ps=3.56u w=3u l=0.55u
X23 VIN EAOUT VOUT VIN pfet_06v0 ad=0.84p pd=3.56u as=0.84p ps=3.56u w=3u l=0.55u
X24 VOUT EAOUT VIN VIN pfet_06v0 ad=0.84p pd=3.56u as=0.84p ps=3.56u w=3u l=0.55u
X25 VIN EAOUT VOUT VIN pfet_06v0 ad=0.84p pd=3.56u as=0.84p ps=3.56u w=3u l=0.55u
X26 VOUT EAOUT VIN VIN pfet_06v0 ad=0.84p pd=3.56u as=0.84p ps=3.56u w=3u l=0.55u
X27 VIN EAOUT VOUT VIN pfet_06v0 ad=0.84p pd=3.56u as=0.84p ps=3.56u w=3u l=0.55u
X28 VIN EAOUT VOUT VIN pfet_06v0 ad=0.84p pd=3.56u as=0.84p ps=3.56u w=3u l=0.55u
X29 VIN EAOUT VOUT VIN pfet_06v0 ad=0.84p pd=3.56u as=0.84p ps=3.56u w=3u l=0.55u
X30 VIN EAOUT VOUT VIN pfet_06v0 ad=0.84p pd=3.56u as=0.84p ps=3.56u w=3u l=0.55u
X31 VIN EAOUT VOUT VIN pfet_06v0 ad=0.84p pd=3.56u as=0.84p ps=3.56u w=3u l=0.55u
X32 VOUT EAOUT VIN VIN pfet_06v0 ad=0.84p pd=3.56u as=0.84p ps=3.56u w=3u l=0.55u
X33 VOUT EAOUT VIN VIN pfet_06v0 ad=0.84p pd=3.56u as=0.84p ps=3.56u w=3u l=0.55u
X34 VIN EAOUT VOUT VIN pfet_06v0 ad=0.84p pd=3.56u as=0.84p ps=3.56u w=3u l=0.55u
X35 VOUT EAOUT VIN VIN pfet_06v0 ad=0.84p pd=3.56u as=0.84p ps=3.56u w=3u l=0.55u
X36 VOUT EAOUT VIN VIN pfet_06v0 ad=0.84p pd=3.56u as=0.84p ps=3.56u w=3u l=0.55u
X37 VOUT EAOUT VIN VIN pfet_06v0 ad=0.84p pd=3.56u as=0.84p ps=3.56u w=3u l=0.55u
X38 VOUT EAOUT VIN VIN pfet_06v0 ad=0.84p pd=3.56u as=0.84p ps=3.56u w=3u l=0.55u
X39 VOUT EAOUT VIN VIN pfet_06v0 ad=0.84p pd=3.56u as=0.84p ps=3.56u w=3u l=0.55u
X40 VIN EAOUT VOUT VIN pfet_06v0 ad=0.84p pd=3.56u as=0.84p ps=3.56u w=3u l=0.55u
X41 VOUT EAOUT VIN VIN pfet_06v0 ad=0.84p pd=3.56u as=0.84p ps=3.56u w=3u l=0.55u
X42 VIN EAOUT VOUT VIN pfet_06v0 ad=0.84p pd=3.56u as=0.84p ps=3.56u w=3u l=0.55u
X43 VOUT EAOUT VIN VIN pfet_06v0 ad=0.84p pd=3.56u as=0.84p ps=3.56u w=3u l=0.55u
X44 VOUT EAOUT VIN VIN pfet_06v0 ad=0.84p pd=3.56u as=0.84p ps=3.56u w=3u l=0.55u
X45 VIN EAOUT VOUT VIN pfet_06v0 ad=0.84p pd=3.56u as=0.84p ps=3.56u w=3u l=0.55u
X46 VOUT EAOUT VIN VIN pfet_06v0 ad=0.84p pd=3.56u as=0.84p ps=3.56u w=3u l=0.55u
X47 VIN EAOUT VOUT VIN pfet_06v0 ad=0.84p pd=3.56u as=0.84p ps=3.56u w=3u l=0.55u
X48 VIN EAOUT VOUT VIN pfet_06v0 ad=1.8p pd=7.2u as=0.84p ps=3.56u w=3u l=0.55u
X49 VOUT EAOUT VIN VIN pfet_06v0 ad=0.84p pd=3.56u as=0.84p ps=3.56u w=3u l=0.55u
X50 VIN EAOUT VOUT VIN pfet_06v0 ad=0.84p pd=3.56u as=0.84p ps=3.56u w=3u l=0.55u
X51 VIN EAOUT VOUT VIN pfet_06v0 ad=0.84p pd=3.56u as=0.84p ps=3.56u w=3u l=0.55u
X52 VIN EAOUT VOUT VIN pfet_06v0 ad=0.84p pd=3.56u as=0.84p ps=3.56u w=3u l=0.55u
X53 VOUT EAOUT VIN VIN pfet_06v0 ad=0.84p pd=3.56u as=0.84p ps=3.56u w=3u l=0.55u
X54 VIN EAOUT VOUT VIN pfet_06v0 ad=0.84p pd=3.56u as=0.84p ps=3.56u w=3u l=0.55u
X55 VOUT EAOUT VIN VIN pfet_06v0 ad=0.84p pd=3.56u as=0.84p ps=3.56u w=3u l=0.55u
X56 VOUT EAOUT VIN VIN pfet_06v0 ad=0.84p pd=3.56u as=0.84p ps=3.56u w=3u l=0.55u
X57 VOUT EAOUT VIN VIN pfet_06v0 ad=0.84p pd=3.56u as=0.84p ps=3.56u w=3u l=0.55u
X58 VIN EAOUT VOUT VIN pfet_06v0 ad=0.84p pd=3.56u as=0.84p ps=3.56u w=3u l=0.55u
X59 VIN EAOUT VOUT VIN pfet_06v0 ad=0.84p pd=3.56u as=0.84p ps=3.56u w=3u l=0.55u
X60 VOUT EAOUT VIN VIN pfet_06v0 ad=0.84p pd=3.56u as=0.84p ps=3.56u w=3u l=0.55u
X61 VIN EAOUT VOUT VIN pfet_06v0 ad=0.84p pd=3.56u as=0.84p ps=3.56u w=3u l=0.55u
X62 VOUT EAOUT VIN VIN pfet_06v0 ad=0.84p pd=3.56u as=0.84p ps=3.56u w=3u l=0.55u
X63 VOUT EAOUT VIN VIN pfet_06v0 ad=0.84p pd=3.56u as=0.84p ps=3.56u w=3u l=0.55u
X64 VIN EAOUT VOUT VIN pfet_06v0 ad=0.84p pd=3.56u as=0.84p ps=3.56u w=3u l=0.55u
X65 VIN EAOUT VOUT VIN pfet_06v0 ad=1.8p pd=7.2u as=0.84p ps=3.56u w=3u l=0.55u
X66 VIN EAOUT VOUT VIN pfet_06v0 ad=0.84p pd=3.56u as=0.84p ps=3.56u w=3u l=0.55u
X67 VOUT EAOUT VIN VIN pfet_06v0 ad=0.84p pd=3.56u as=0.84p ps=3.56u w=3u l=0.55u
X68 VOUT EAOUT VIN VIN pfet_06v0 ad=0.84p pd=3.56u as=0.84p ps=3.56u w=3u l=0.55u
X69 VOUT EAOUT VIN VIN pfet_06v0 ad=0.84p pd=3.56u as=0.84p ps=3.56u w=3u l=0.55u
X70 VIN EAOUT VOUT VIN pfet_06v0 ad=0.84p pd=3.56u as=0.84p ps=3.56u w=3u l=0.55u
X71 VOUT EAOUT VIN VIN pfet_06v0 ad=0.84p pd=3.56u as=0.84p ps=3.56u w=3u l=0.55u
X72 VIN EAOUT VOUT VIN pfet_06v0 ad=0.84p pd=3.56u as=0.84p ps=3.56u w=3u l=0.55u
X73 VIN EAOUT VOUT VIN pfet_06v0 ad=0.84p pd=3.56u as=0.84p ps=3.56u w=3u l=0.55u
X74 VIN EAOUT VOUT VIN pfet_06v0 ad=0.84p pd=3.56u as=0.84p ps=3.56u w=3u l=0.55u
X75 VOUT EAOUT VIN VIN pfet_06v0 ad=0.84p pd=3.56u as=0.84p ps=3.56u w=3u l=0.55u
X76 VIN EAOUT VOUT VIN pfet_06v0 ad=0.84p pd=3.56u as=0.84p ps=3.56u w=3u l=0.55u
X77 VOUT EAOUT VIN VIN pfet_06v0 ad=0.84p pd=3.56u as=0.84p ps=3.56u w=3u l=0.55u
X78 VIN EAOUT VOUT VIN pfet_06v0 ad=0.84p pd=3.56u as=0.84p ps=3.56u w=3u l=0.55u
X79 VIN EAOUT VOUT VIN pfet_06v0 ad=1.8p pd=7.2u as=0.84p ps=3.56u w=3u l=0.55u
X80 VOUT EAOUT VIN VIN pfet_06v0 ad=0.84p pd=3.56u as=0.84p ps=3.56u w=3u l=0.55u
X81 VIN EAOUT VOUT VIN pfet_06v0 ad=0.84p pd=3.56u as=0.84p ps=3.56u w=3u l=0.55u
X82 VOUT EAOUT VIN VIN pfet_06v0 ad=0.84p pd=3.56u as=0.84p ps=3.56u w=3u l=0.55u
X83 VIN EAOUT VOUT VIN pfet_06v0 ad=0.84p pd=3.56u as=0.84p ps=3.56u w=3u l=0.55u
X84 VIN EAOUT VOUT VIN pfet_06v0 ad=0.84p pd=3.56u as=0.84p ps=3.56u w=3u l=0.55u
X85 VIN EAOUT VOUT VIN pfet_06v0 ad=0.84p pd=3.56u as=0.84p ps=3.56u w=3u l=0.55u
X86 VOUT EAOUT VIN VIN pfet_06v0 ad=0.84p pd=3.56u as=0.84p ps=3.56u w=3u l=0.55u
X87 VIN EAOUT VOUT VIN pfet_06v0 ad=1.8p pd=7.2u as=0.84p ps=3.56u w=3u l=0.55u
X88 VOUT EAOUT VIN VIN pfet_06v0 ad=0.84p pd=3.56u as=0.84p ps=3.56u w=3u l=0.55u
X89 VIN EAOUT VOUT VIN pfet_06v0 ad=0.84p pd=3.56u as=0.84p ps=3.56u w=3u l=0.55u
X90 VIN EAOUT VOUT VIN pfet_06v0 ad=0.84p pd=3.56u as=0.84p ps=3.56u w=3u l=0.55u
X91 VIN EAOUT VOUT VIN pfet_06v0 ad=0.84p pd=3.56u as=0.84p ps=3.56u w=3u l=0.55u
X92 VIN EAOUT VOUT VIN pfet_06v0 ad=0.84p pd=3.56u as=0.84p ps=3.56u w=3u l=0.55u
X93 VIN EAOUT VOUT VIN pfet_06v0 ad=0.84p pd=3.56u as=0.84p ps=3.56u w=3u l=0.55u
X94 VOUT EAOUT VIN VIN pfet_06v0 ad=0.84p pd=3.56u as=0.84p ps=3.56u w=3u l=0.55u
X95 VIN EAOUT VOUT VIN pfet_06v0 ad=0.84p pd=3.56u as=0.84p ps=3.56u w=3u l=0.55u
X96 VIN EAOUT VOUT VIN pfet_06v0 ad=0.84p pd=3.56u as=0.84p ps=3.56u w=3u l=0.55u
X97 VIN EAOUT VOUT VIN pfet_06v0 ad=0.84p pd=3.56u as=0.84p ps=3.56u w=3u l=0.55u
X98 VIN EAOUT VOUT VIN pfet_06v0 ad=0.84p pd=3.56u as=0.84p ps=3.56u w=3u l=0.55u
X99 VIN EAOUT VOUT VIN pfet_06v0 ad=0.84p pd=3.56u as=0.84p ps=3.56u w=3u l=0.55u
X100 VOUT EAOUT VIN VIN pfet_06v0 ad=0.84p pd=3.56u as=1.8p ps=7.2u w=3u l=0.55u
X101 VIN EAOUT VOUT VIN pfet_06v0 ad=0.84p pd=3.56u as=0.84p ps=3.56u w=3u l=0.55u
X102 VIN EAOUT VOUT VIN pfet_06v0 ad=0.84p pd=3.56u as=0.84p ps=3.56u w=3u l=0.55u
X103 VIN EAOUT VOUT VIN pfet_06v0 ad=0.84p pd=3.56u as=0.84p ps=3.56u w=3u l=0.55u
X104 VIN EAOUT VOUT VIN pfet_06v0 ad=0.84p pd=3.56u as=0.84p ps=3.56u w=3u l=0.55u
X105 VIN EAOUT VOUT VIN pfet_06v0 ad=0.84p pd=3.56u as=0.84p ps=3.56u w=3u l=0.55u
X106 VOUT EAOUT VIN VIN pfet_06v0 ad=0.84p pd=3.56u as=0.84p ps=3.56u w=3u l=0.55u
X107 VOUT EAOUT VIN VIN pfet_06v0 ad=0.84p pd=3.56u as=0.84p ps=3.56u w=3u l=0.55u
X108 VOUT EAOUT VIN VIN pfet_06v0 ad=0.84p pd=3.56u as=0.84p ps=3.56u w=3u l=0.55u
X109 VOUT EAOUT VIN VIN pfet_06v0 ad=0.84p pd=3.56u as=0.84p ps=3.56u w=3u l=0.55u
X110 VOUT EAOUT VIN VIN pfet_06v0 ad=0.84p pd=3.56u as=1.8p ps=7.2u w=3u l=0.55u
X111 VIN EAOUT VOUT VIN pfet_06v0 ad=0.84p pd=3.56u as=0.84p ps=3.56u w=3u l=0.55u
X112 VIN EAOUT VOUT VIN pfet_06v0 ad=0.84p pd=3.56u as=0.84p ps=3.56u w=3u l=0.55u
X113 VIN EAOUT VOUT VIN pfet_06v0 ad=0.84p pd=3.56u as=0.84p ps=3.56u w=3u l=0.55u
X114 VOUT EAOUT VIN VIN pfet_06v0 ad=0.84p pd=3.56u as=0.84p ps=3.56u w=3u l=0.55u
X115 VOUT EAOUT VIN VIN pfet_06v0 ad=0.84p pd=3.56u as=0.84p ps=3.56u w=3u l=0.55u
X116 VIN EAOUT VOUT VIN pfet_06v0 ad=0.84p pd=3.56u as=0.84p ps=3.56u w=3u l=0.55u
X117 VOUT EAOUT VIN VIN pfet_06v0 ad=0.84p pd=3.56u as=0.84p ps=3.56u w=3u l=0.55u
X118 VOUT EAOUT VIN VIN pfet_06v0 ad=0.84p pd=3.56u as=0.84p ps=3.56u w=3u l=0.55u
X119 VOUT EAOUT VIN VIN pfet_06v0 ad=0.84p pd=3.56u as=0.84p ps=3.56u w=3u l=0.55u
X120 VIN EAOUT VOUT VIN pfet_06v0 ad=0.84p pd=3.56u as=0.84p ps=3.56u w=3u l=0.55u
X121 VIN EAOUT VOUT VIN pfet_06v0 ad=0.84p pd=3.56u as=0.84p ps=3.56u w=3u l=0.55u
X122 VIN EAOUT VOUT VIN pfet_06v0 ad=0.84p pd=3.56u as=0.84p ps=3.56u w=3u l=0.55u
X123 VOUT EAOUT VIN VIN pfet_06v0 ad=0.84p pd=3.56u as=1.8p ps=7.2u w=3u l=0.55u
X124 VIN EAOUT VOUT VIN pfet_06v0 ad=0.84p pd=3.56u as=0.84p ps=3.56u w=3u l=0.55u
X125 VOUT EAOUT VIN VIN pfet_06v0 ad=0.84p pd=3.56u as=1.8p ps=7.2u w=3u l=0.55u
X126 VOUT EAOUT VIN VIN pfet_06v0 ad=0.84p pd=3.56u as=0.84p ps=3.56u w=3u l=0.55u
X127 VIN EAOUT VOUT VIN pfet_06v0 ad=0.84p pd=3.56u as=0.84p ps=3.56u w=3u l=0.55u
X128 VIN EAOUT VOUT VIN pfet_06v0 ad=0.84p pd=3.56u as=0.84p ps=3.56u w=3u l=0.55u
X129 VOUT EAOUT VIN VIN pfet_06v0 ad=0.84p pd=3.56u as=0.84p ps=3.56u w=3u l=0.55u
X130 VIN EAOUT VOUT VIN pfet_06v0 ad=0.84p pd=3.56u as=0.84p ps=3.56u w=3u l=0.55u
X131 VOUT EAOUT VIN VIN pfet_06v0 ad=0.84p pd=3.56u as=0.84p ps=3.56u w=3u l=0.55u
X132 VOUT EAOUT VIN VIN pfet_06v0 ad=0.84p pd=3.56u as=0.84p ps=3.56u w=3u l=0.55u
X133 VOUT EAOUT VIN VIN pfet_06v0 ad=0.84p pd=3.56u as=0.84p ps=3.56u w=3u l=0.55u
X134 VIN EAOUT VOUT VIN pfet_06v0 ad=0.84p pd=3.56u as=0.84p ps=3.56u w=3u l=0.55u
X135 VOUT EAOUT VIN VIN pfet_06v0 ad=0.84p pd=3.56u as=0.84p ps=3.56u w=3u l=0.55u
X136 VOUT EAOUT VIN VIN pfet_06v0 ad=0.84p pd=3.56u as=0.84p ps=3.56u w=3u l=0.55u
X137 VIN EAOUT VOUT VIN pfet_06v0 ad=0.84p pd=3.56u as=0.84p ps=3.56u w=3u l=0.55u
X138 VOUT EAOUT VIN VIN pfet_06v0 ad=0.84p pd=3.56u as=0.84p ps=3.56u w=3u l=0.55u
X139 VIN EAOUT VOUT VIN pfet_06v0 ad=0.84p pd=3.56u as=0.84p ps=3.56u w=3u l=0.55u
X140 VOUT EAOUT VIN VIN pfet_06v0 ad=0.84p pd=3.56u as=0.84p ps=3.56u w=3u l=0.55u
X141 VOUT EAOUT VIN VIN pfet_06v0 ad=0.84p pd=3.56u as=0.84p ps=3.56u w=3u l=0.55u
X142 VOUT EAOUT VIN VIN pfet_06v0 ad=0.84p pd=3.56u as=0.84p ps=3.56u w=3u l=0.55u
X143 VOUT EAOUT VIN VIN pfet_06v0 ad=0.84p pd=3.56u as=0.84p ps=3.56u w=3u l=0.55u
X144 VOUT EAOUT VIN VIN pfet_06v0 ad=0.84p pd=3.56u as=0.84p ps=3.56u w=3u l=0.55u
X145 VIN EAOUT VOUT VIN pfet_06v0 ad=0.84p pd=3.56u as=0.84p ps=3.56u w=3u l=0.55u
X146 VIN EAOUT VOUT VIN pfet_06v0 ad=0.84p pd=3.56u as=0.84p ps=3.56u w=3u l=0.55u
X147 VOUT EAOUT VIN VIN pfet_06v0 ad=0.84p pd=3.56u as=0.84p ps=3.56u w=3u l=0.55u
X148 VOUT EAOUT VIN VIN pfet_06v0 ad=0.84p pd=3.56u as=0.84p ps=3.56u w=3u l=0.55u
X149 VOUT EAOUT VIN VIN pfet_06v0 ad=0.84p pd=3.56u as=0.84p ps=3.56u w=3u l=0.55u
X150 VOUT EAOUT VIN VIN pfet_06v0 ad=0.84p pd=3.56u as=0.84p ps=3.56u w=3u l=0.55u
X151 VIN EAOUT VOUT VIN pfet_06v0 ad=0.84p pd=3.56u as=0.84p ps=3.56u w=3u l=0.55u
X152 VIN EAOUT VOUT VIN pfet_06v0 ad=0.84p pd=3.56u as=0.84p ps=3.56u w=3u l=0.55u
X153 VOUT EAOUT VIN VIN pfet_06v0 ad=0.84p pd=3.56u as=0.84p ps=3.56u w=3u l=0.55u
X154 VOUT EAOUT VIN VIN pfet_06v0 ad=0.84p pd=3.56u as=0.84p ps=3.56u w=3u l=0.55u
X155 VOUT EAOUT VIN VIN pfet_06v0 ad=0.84p pd=3.56u as=0.84p ps=3.56u w=3u l=0.55u
X156 VOUT EAOUT VIN VIN pfet_06v0 ad=0.84p pd=3.56u as=0.84p ps=3.56u w=3u l=0.55u
X157 VIN EAOUT VOUT VIN pfet_06v0 ad=0.84p pd=3.56u as=0.84p ps=3.56u w=3u l=0.55u
X158 VIN EAOUT VOUT VIN pfet_06v0 ad=0.84p pd=3.56u as=0.84p ps=3.56u w=3u l=0.55u
X159 VIN EAOUT VOUT VIN pfet_06v0 ad=0.84p pd=3.56u as=0.84p ps=3.56u w=3u l=0.55u
X160 VOUT EAOUT VIN VIN pfet_06v0 ad=0.84p pd=3.56u as=0.84p ps=3.56u w=3u l=0.55u
X161 VOUT EAOUT VIN VIN pfet_06v0 ad=0.84p pd=3.56u as=0.84p ps=3.56u w=3u l=0.55u
X162 VIN EAOUT VOUT VIN pfet_06v0 ad=0.84p pd=3.56u as=0.84p ps=3.56u w=3u l=0.55u
X163 VOUT EAOUT VIN VIN pfet_06v0 ad=0.84p pd=3.56u as=0.84p ps=3.56u w=3u l=0.55u
X164 VIN EAOUT VOUT VIN pfet_06v0 ad=0.84p pd=3.56u as=0.84p ps=3.56u w=3u l=0.55u
X165 VIN EAOUT VOUT VIN pfet_06v0 ad=0.84p pd=3.56u as=0.84p ps=3.56u w=3u l=0.55u
X166 VOUT EAOUT VIN VIN pfet_06v0 ad=0.84p pd=3.56u as=0.84p ps=3.56u w=3u l=0.55u
X167 VOUT EAOUT VIN VIN pfet_06v0 ad=0.84p pd=3.56u as=1.8p ps=7.2u w=3u l=0.55u
X168 VIN EAOUT VOUT VIN pfet_06v0 ad=0.84p pd=3.56u as=0.84p ps=3.56u w=3u l=0.55u
X169 VIN EAOUT VOUT VIN pfet_06v0 ad=0.84p pd=3.56u as=0.84p ps=3.56u w=3u l=0.55u
X170 VOUT EAOUT VIN VIN pfet_06v0 ad=0.84p pd=3.56u as=0.84p ps=3.56u w=3u l=0.55u
X171 VIN EAOUT VOUT VIN pfet_06v0 ad=1.8p pd=7.2u as=0.84p ps=3.56u w=3u l=0.55u
X172 VOUT EAOUT VIN VIN pfet_06v0 ad=0.84p pd=3.56u as=0.84p ps=3.56u w=3u l=0.55u
X173 VOUT EAOUT VIN VIN pfet_06v0 ad=0.84p pd=3.56u as=0.84p ps=3.56u w=3u l=0.55u
X174 VIN EAOUT VOUT VIN pfet_06v0 ad=0.84p pd=3.56u as=0.84p ps=3.56u w=3u l=0.55u
X175 VOUT EAOUT VIN VIN pfet_06v0 ad=0.84p pd=3.56u as=0.84p ps=3.56u w=3u l=0.55u
X176 VIN EAOUT VOUT VIN pfet_06v0 ad=0.84p pd=3.56u as=0.84p ps=3.56u w=3u l=0.55u
X177 VOUT EAOUT VIN VIN pfet_06v0 ad=0.84p pd=3.56u as=0.84p ps=3.56u w=3u l=0.55u
X178 VOUT EAOUT VIN VIN pfet_06v0 ad=0.84p pd=3.56u as=0.84p ps=3.56u w=3u l=0.55u
X179 VIN EAOUT VOUT VIN pfet_06v0 ad=0.84p pd=3.56u as=0.84p ps=3.56u w=3u l=0.55u
X180 VOUT EAOUT VIN VIN pfet_06v0 ad=0.84p pd=3.56u as=0.84p ps=3.56u w=3u l=0.55u
X181 VOUT EAOUT VIN VIN pfet_06v0 ad=0.84p pd=3.56u as=0.84p ps=3.56u w=3u l=0.55u
X182 VIN EAOUT VOUT VIN pfet_06v0 ad=0.84p pd=3.56u as=0.84p ps=3.56u w=3u l=0.55u
X183 VOUT EAOUT VIN VIN pfet_06v0 ad=0.84p pd=3.56u as=0.84p ps=3.56u w=3u l=0.55u
X184 VOUT EAOUT VIN VIN pfet_06v0 ad=0.84p pd=3.56u as=0.84p ps=3.56u w=3u l=0.55u
X185 VIN EAOUT VOUT VIN pfet_06v0 ad=0.84p pd=3.56u as=0.84p ps=3.56u w=3u l=0.55u
X186 VIN EAOUT VOUT VIN pfet_06v0 ad=0.84p pd=3.56u as=0.84p ps=3.56u w=3u l=0.55u
X187 VOUT EAOUT VIN VIN pfet_06v0 ad=0.84p pd=3.56u as=0.84p ps=3.56u w=3u l=0.55u
X188 VIN EAOUT VOUT VIN pfet_06v0 ad=0.84p pd=3.56u as=0.84p ps=3.56u w=3u l=0.55u
X189 VIN EAOUT VOUT VIN pfet_06v0 ad=0.84p pd=3.56u as=0.84p ps=3.56u w=3u l=0.55u
X190 VOUT EAOUT VIN VIN pfet_06v0 ad=0.84p pd=3.56u as=0.84p ps=3.56u w=3u l=0.55u
X191 VIN EAOUT VOUT VIN pfet_06v0 ad=0.84p pd=3.56u as=0.84p ps=3.56u w=3u l=0.55u
X192 VIN EAOUT VOUT VIN pfet_06v0 ad=0.84p pd=3.56u as=0.84p ps=3.56u w=3u l=0.55u
X193 VIN EAOUT VOUT VIN pfet_06v0 ad=0.84p pd=3.56u as=0.84p ps=3.56u w=3u l=0.55u
X194 VIN EAOUT VOUT VIN pfet_06v0 ad=0.84p pd=3.56u as=0.84p ps=3.56u w=3u l=0.55u
X195 VIN EAOUT VOUT VIN pfet_06v0 ad=0.84p pd=3.56u as=0.84p ps=3.56u w=3u l=0.55u
X196 VOUT EAOUT VIN VIN pfet_06v0 ad=0.84p pd=3.56u as=0.84p ps=3.56u w=3u l=0.55u
X197 VIN EAOUT VOUT VIN pfet_06v0 ad=0.84p pd=3.56u as=0.84p ps=3.56u w=3u l=0.55u
X198 VOUT EAOUT VIN VIN pfet_06v0 ad=0.84p pd=3.56u as=0.84p ps=3.56u w=3u l=0.55u
X199 VIN EAOUT VOUT VIN pfet_06v0 ad=0.84p pd=3.56u as=0.84p ps=3.56u w=3u l=0.55u
X200 VOUT EAOUT VIN VIN pfet_06v0 ad=0.84p pd=3.56u as=0.84p ps=3.56u w=3u l=0.55u
X201 VIN EAOUT VOUT VIN pfet_06v0 ad=0.84p pd=3.56u as=0.84p ps=3.56u w=3u l=0.55u
X202 VOUT EAOUT VIN VIN pfet_06v0 ad=0.84p pd=3.56u as=0.84p ps=3.56u w=3u l=0.55u
X203 VIN EAOUT VOUT VIN pfet_06v0 ad=0.84p pd=3.56u as=0.84p ps=3.56u w=3u l=0.55u
X204 VIN EAOUT VOUT VIN pfet_06v0 ad=0.84p pd=3.56u as=0.84p ps=3.56u w=3u l=0.55u
X205 VIN EAOUT VOUT VIN pfet_06v0 ad=0.84p pd=3.56u as=0.84p ps=3.56u w=3u l=0.55u
X206 VOUT EAOUT VIN VIN pfet_06v0 ad=0.84p pd=3.56u as=0.84p ps=3.56u w=3u l=0.55u
X207 VOUT EAOUT VIN VIN pfet_06v0 ad=0.84p pd=3.56u as=0.84p ps=3.56u w=3u l=0.55u
X208 VOUT EAOUT VIN VIN pfet_06v0 ad=0.84p pd=3.56u as=0.84p ps=3.56u w=3u l=0.55u
X209 VOUT EAOUT VIN VIN pfet_06v0 ad=0.84p pd=3.56u as=0.84p ps=3.56u w=3u l=0.55u
X210 VIN EAOUT VOUT VIN pfet_06v0 ad=0.84p pd=3.56u as=0.84p ps=3.56u w=3u l=0.55u
X211 VIN EAOUT VOUT VIN pfet_06v0 ad=0.84p pd=3.56u as=0.84p ps=3.56u w=3u l=0.55u
X212 VOUT EAOUT VIN VIN pfet_06v0 ad=0.84p pd=3.56u as=0.84p ps=3.56u w=3u l=0.55u
X213 VOUT EAOUT VIN VIN pfet_06v0 ad=0.84p pd=3.56u as=0.84p ps=3.56u w=3u l=0.55u
X214 VOUT EAOUT VIN VIN pfet_06v0 ad=0.84p pd=3.56u as=1.8p ps=7.2u w=3u l=0.55u
X215 VOUT EAOUT VIN VIN pfet_06v0 ad=0.84p pd=3.56u as=0.84p ps=3.56u w=3u l=0.55u
X216 VIN EAOUT VOUT VIN pfet_06v0 ad=0.84p pd=3.56u as=0.84p ps=3.56u w=3u l=0.55u
X217 VOUT EAOUT VIN VIN pfet_06v0 ad=0.84p pd=3.56u as=0.84p ps=3.56u w=3u l=0.55u
X218 m1_19868_3148# m2_1805_3723# VSS VSS nfet_05v0 ad=0.6p pd=3.2u as=0.6p ps=3.2u w=1u l=0.6u
X219 VOUT m2_1805_3723# VSS VSS nfet_05v0 ad=3p pd=11.2u as=0 ps=0 w=5u l=0.6u
X220 m2_1805_3723# VSS VIN VIN pfet_06v0 ad=0.6p pd=3.2u as=0.6p ps=3.2u w=1u l=40u
X221 m2_3642_4622# m2_1805_3723# VIN VIN pfet_06v0 ad=3p pd=11.2u as=0.23184n ps=0.96064m w=5u l=0.6u
X222 R1R2/m1_n2438_4985# R1R2/m1_n1958_n5053# VSS ppolyf_u_1k_6p0 r_width=2u r_length=49.33u
X223 R1R2/m1_n998_4985# R1R2/m1_n38_n5053# VSS ppolyf_u_1k_6p0 r_width=2u r_length=49.33u
X224 R1R2/m1_n1478_4985# R1R2/m1_n518_n5053# VSS ppolyf_u_1k_6p0 r_width=2u r_length=49.33u
X225 R1R2/m1_n998_4985# R1R2/m1_n1958_n5053# VSS ppolyf_u_1k_6p0 r_width=2u r_length=49.33u
X226 R1R2/m1_n1478_4985# VSS VSS ppolyf_u_1k_6p0 r_width=2u r_length=49.33u
X229 R1R2/m1_n2438_4985# FB VSS ppolyf_u_1k_6p0 r_width=2u r_length=49.33u
X230 VOUT R1R2/m1_1882_n5053# VSS ppolyf_u_1k_6p0 r_width=2u r_length=49.33u
X231 R1R2/m1_442_4985# FB VSS ppolyf_u_1k_6p0 r_width=2u r_length=49.33u
X232 R1R2/m1_922_4985# R1R2/m1_1882_n5053# VSS ppolyf_u_1k_6p0 r_width=2u r_length=49.33u
X233 R1R2/m1_442_4985# R1R2/m1_n518_n5053# VSS ppolyf_u_1k_6p0 r_width=2u r_length=49.33u
X234 R1R2/m1_922_4985# R1R2/m1_n38_n5053# VSS ppolyf_u_1k_6p0 r_width=2u r_length=49.33u
X235 m2_1805_3723# EN VSS VSS nfet_06v0 ad=0.3p pd=2.2u as=0.3p ps=2.2u w=0.5u l=5u
X236 m2_3642_4622# m2_1805_3723# VSS VSS nfet_05v0 ad=3p pd=11.2u as=0 ps=0 w=5u l=0.6u
X237 m1_11624_14632# m1_704_14632# VSS ppolyf_u_1k_6p0 r_width=1u r_length=1.94754m
X238 m1_704_14632# m2_1805_3723# VSS VSS nfet_05v0 ad=3.6p pd=15.6u as=0 ps=0 w=1u l=0.6u
X239 VIN m2_1805_3723# m1_11624_14632# VIN pfet_06v0 ad=3p pd=11.2u as=1.4p ps=5.56u w=5u l=0.6u
X240 m1_11624_14632# m2_1805_3723# VIN VIN pfet_06v0 ad=1.4p pd=5.56u as=3p ps=11.2u w=5u l=0.6u
X241 m2_25811_10472# m2_25811_10472# VIN VIN pfet_06v0 ad=3p pd=11.2u as=3p ps=11.2u w=5u l=3u
X243 m2_26051_10742# m2_25811_10472# VIN VIN pfet_06v0 ad=3p pd=11.2u as=3p ps=11.2u w=5u l=3u
X244 m2_26051_10742# m2_25811_10472# VIN VIN pfet_06v0 ad=3p pd=11.2u as=3p ps=11.2u w=5u l=3u
X246 m2_25811_10472# m2_25811_10472# VIN VIN pfet_06v0 ad=3p pd=11.2u as=3p ps=11.2u w=5u l=3u
X248 EAOUT_BUF m1_704_14632# VSS VSS nfet_05v0 ad=1.5p pd=6.2u as=1.5p ps=6.2u w=2.5u l=0.6u
X249 m1_704_14632# m1_704_14632# VSS VSS nfet_05v0 ad=1.5p pd=6.2u as=1.5p ps=6.2u w=2.5u l=0.6u
X250 EAOUT_BUF m1_704_14632# VSS VSS nfet_05v0 ad=1.5p pd=6.2u as=1.5p ps=6.2u w=2.5u l=0.6u
X252 FB_BUF m1_704_14632# VSS VSS nfet_05v0 ad=1.5p pd=6.2u as=1.5p ps=6.2u w=2.5u l=0.6u
X253 m1_704_14632# m1_704_14632# VSS VSS nfet_05v0 ad=1.5p pd=6.2u as=1.5p ps=6.2u w=2.5u l=0.6u
X254 FB_BUF m1_704_14632# VSS VSS nfet_05v0 ad=1.5p pd=6.2u as=1.5p ps=6.2u w=2.5u l=0.6u
X255 VIN FB FB_BUF VSS nfet_05v0 ad=0.17781n pd=0.97688m as=6p ps=23.6u w=5u l=0.6u
X256 m1_11624_14632# m1_19868_3148# VSS ppolyf_u_1k_6p0 r_width=1u r_length=0.19609m
X257 EAOUT m2_24210_7554# m2_26051_10742# VIN pfet_06v0 ad=1.5p pd=6.2u as=1.5p ps=6.2u w=2.5u l=0.55u
X259 m2_25811_10472# m2_24210_7554# m2_24210_7554# VIN pfet_06v0 ad=1.5p pd=6.2u as=1.5p ps=6.2u w=2.5u l=0.55u
X260 EAOUT m2_24210_7554# m2_26051_10742# VIN pfet_06v0 ad=1.5p pd=6.2u as=1.5p ps=6.2u w=2.5u l=0.55u
X261 m2_25811_10472# m2_24210_7554# m2_24210_7554# VIN pfet_06v0 ad=1.5p pd=6.2u as=1.5p ps=6.2u w=2.5u l=0.55u
X263 EAOUT VOUT cap_mim_2f0_m4m5_noshield c_width=38.6u c_length=38.6u
X264 m2_24210_7554# FB m2_28581_4772# VSS nfet_06v0 ad=6p pd=21.2u as=6p ps=21.2u w=10u l=3u
X265 EAOUT VREF m2_28581_4772# VSS nfet_06v0 ad=6p pd=21.2u as=6p ps=21.2u w=10u l=3u
X266 m2_24210_7554# FB m2_28581_4772# VSS nfet_06v0 ad=6p pd=21.2u as=6p ps=21.2u w=10u l=3u
X267 EAOUT VREF m2_28581_4772# VSS nfet_06v0 ad=6p pd=21.2u as=6p ps=21.2u w=10u l=3u
