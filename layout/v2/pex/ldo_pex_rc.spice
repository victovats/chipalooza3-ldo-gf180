* NGSPICE file created from ldo_flat.ext - technology: gf180mcuD

.subckt ldo_flat EAOUT_BUF FB_BUF EN VREF VIN VOUT VSS
X0 VIN.t303 EAOUT.t45 VOUT.t173 VIN.t183 pfet_06v0 ad=0.84p pd=3.56u as=0.84p ps=3.56u w=3u l=0.55u
X1 VOUT.t31 EAOUT.t116 VIN.t68 VIN.t45 pfet_06v0 ad=0.84p pd=3.56u as=0.84p ps=3.56u w=3u l=0.55u
X2 VIN.t259 EAOUT.t83 VOUT.t135 VIN.t127 pfet_06v0 ad=0.84p pd=3.56u as=0.84p ps=3.56u w=3u l=0.55u
X3 a_22144_9605.t0 a_22144_8265.t18 VIN.t23 VIN.t22 pfet_06v0 ad=0.7p pd=3.06u as=0.7p ps=3.06u w=2.5u l=3u
X4 VIN.t284 EAOUT.t123 VOUT.t155 VIN.t173 pfet_06v0 ad=0.84p pd=3.56u as=0.84p ps=3.56u w=3u l=0.55u
X5 VIN.t289 EAOUT.t103 VOUT.t160 VIN.t2 pfet_06v0 ad=0.84p pd=3.56u as=0.84p ps=3.56u w=3u l=0.55u
X6 VOUT.t179 EAOUT.t96 VIN.t309 VIN.t41 pfet_06v0 ad=0.84p pd=3.56u as=0.84p ps=3.56u w=3u l=0.55u
X7 VOUT.t12 a_16652_8722# VSS.t65 ppolyf_u_1k_6p0 r_width=2u r_length=49.33u
X8 VIN.t212 EAOUT.t219 VOUT.t124 VIN.t83 pfet_06v0 ad=0.84p pd=3.56u as=0.84p ps=3.56u w=3u l=0.55u
X9 VOUT.t76 EAOUT.t212 VIN.t148 VIN.t89 pfet_06v0 ad=0.84p pd=3.56u as=0.84p ps=3.56u w=3u l=0.55u
X10 VIN.t205 EAOUT.t165 VOUT.t117 VIN.t10 pfet_06v0 ad=0.84p pd=3.56u as=0.84p ps=3.56u w=3u l=0.55u
X11 VOUT.t177 EAOUT.t158 VIN.t307 VIN.t8 pfet_06v0 ad=0.84p pd=3.56u as=0.84p ps=3.56u w=3u l=0.55u
X12 VIN.t343 EAOUT.t135 VOUT.t209 VIN.t98 pfet_06v0 ad=0.84p pd=3.56u as=0.84p ps=3.56u w=3u l=0.55u
X13 VOUT.t188 EAOUT.t128 VIN.t318 VIN.t28 pfet_06v0 ad=0.84p pd=3.56u as=0.84p ps=3.56u w=3u l=0.55u
X14 VOUT.t210 EAOUT.t112 VIN.t344 VIN.t102 pfet_06v0 ad=0.84p pd=3.56u as=0.84p ps=3.56u w=3u l=0.55u
X15 a_22144_9605.t9 VIN.t239 a_22144_9605.t8 VIN.t240 pfet_06v0 ad=1.5p pd=6.2u as=0 ps=0 w=2.5u l=3u
X16 VOUT.t201 EAOUT.t196 VIN.t335 VIN.t290 pfet_06v0 ad=0.84p pd=3.56u as=0.84p ps=3.56u w=3u l=0.55u
X17 VOUT.t98 EAOUT.t190 VIN.t180 VIN.t138 pfet_06v0 ad=0.84p pd=3.56u as=0.84p ps=3.56u w=3u l=0.55u
X18 EAOUT.t4 VSS.t26 EAOUT.t3 VSS.t27 nfet_06v0 ad=1.4p pd=5.56u as=0 ps=0 w=5u l=3u
X19 VIN.t254 VIN.t252 VIN.t253 VIN.t244 pfet_06v0 ad=1.45p pd=6.16u as=0 ps=0 w=2.5u l=3u
X20 VOUT.t68 EAOUT.t82 VIN.t140 VIN.t125 pfet_06v0 ad=0.84p pd=3.56u as=0.84p ps=3.56u w=3u l=0.55u
X21 VOUT.t138 EAOUT.t66 VIN.t267 VIN.t162 pfet_06v0 ad=0.84p pd=3.56u as=0.84p ps=3.56u w=3u l=0.55u
X22 VIN.t271 EAOUT.t35 VOUT.t142 VIN.t197 pfet_06v0 ad=0.84p pd=3.56u as=0.84p ps=3.56u w=3u l=0.55u
X23 VOUT.t29 EAOUT.t28 VIN.t62 VIN.t61 pfet_06v0 ad=0.84p pd=3.56u as=0.84p ps=3.56u w=3u l=0.55u
X24 a_23576_3894.t3 VREF.t3 EAOUT.t5 VSS.t58 nfet_06v0 ad=1.4p pd=5.56u as=1.4p ps=5.56u w=5u l=3u
X25 VSS.t92 IREF.t12 a_23576_3894.t9 VSS.t91 nfet_05v0 ad=0.35p pd=1.81u as=0.35p ps=1.81u w=1.25u l=0.6u
X26 VOUT.t3 EAOUT.t78 VIN.t7 VIN.t6 pfet_06v0 ad=0.84p pd=3.56u as=0.84p ps=3.56u w=3u l=0.55u
X27 VOUT.t30 EAOUT.t44 VIN.t64 VIN.t63 pfet_06v0 ad=0.84p pd=3.56u as=0.84p ps=3.56u w=3u l=0.55u
X28 VIN.t234 VIN.t231 VIN.t233 VIN.t232 pfet_06v0 ad=0.725p pd=3.66u as=0 ps=0 w=1.25u l=0.55u
X29 VIN.t257 EAOUT.t17 VOUT.t134 VIN.t58 pfet_06v0 ad=0.84p pd=3.56u as=0.84p ps=3.56u w=3u l=0.55u
X30 VOUT.t19 EAOUT.t24 VIN.t44 VIN.t43 pfet_06v0 ad=0.84p pd=3.56u as=0.84p ps=3.56u w=3u l=0.55u
X31 VSS.t55 VSS.t52 VSS.t54 VSS.t53 nfet_05v0 ad=0.725p pd=3.66u as=0 ps=0 w=1.25u l=0.6u
X32 VSS.t39 VSS.t37 VSS.t38 VSS.t29 nfet_06v0 ad=2.9p pd=11.16u as=0 ps=0 w=5u l=3u
X33 VIN.t141 EAOUT.t49 VOUT.t69 VIN.t71 pfet_06v0 ad=0.84p pd=3.56u as=0.84p ps=3.56u w=3u l=0.55u
X34 VOUT.t40 EAOUT.t150 VIN.t86 VIN.t85 pfet_06v0 ad=0.84p pd=3.56u as=0.84p ps=3.56u w=3u l=0.55u
X35 VIN.t275 EAOUT.t143 VOUT.t146 VIN.t149 pfet_06v0 ad=0.84p pd=3.56u as=0.84p ps=3.56u w=3u l=0.55u
X36 VIN.t317 EAOUT.t127 VOUT.t187 VIN.t105 pfet_06v0 ad=0.84p pd=3.56u as=0.84p ps=3.56u w=3u l=0.55u
X37 VIN.t121 EAOUT.t89 VOUT.t56 VIN.t120 pfet_06v0 ad=0.84p pd=3.56u as=0.84p ps=3.56u w=3u l=0.55u
X38 v2_pmos_core.EAREF.t9 VIN.t227 a_22144_9605.t12 VIN.t228 pfet_06v0 ad=0.35p pd=1.81u as=0.35p ps=1.81u w=1.25u l=0.55u
X39 VIN.t158 EAOUT.t211 VOUT.t83 VIN.t157 pfet_06v0 ad=0.84p pd=3.56u as=0.84p ps=3.56u w=3u l=0.55u
X40 VOUT.t121 EAOUT.t216 VIN.t209 VIN.t91 pfet_06v0 ad=0.84p pd=3.56u as=0.84p ps=3.56u w=3u l=0.55u
X41 VIN.t200 EAOUT.t169 VOUT.t113 VIN.t24 pfet_06v0 ad=0.84p pd=3.56u as=0.84p ps=3.56u w=3u l=0.55u
X42 VOUT.t170 EAOUT.t162 VIN.t300 VIN.t93 pfet_06v0 ad=0.84p pd=3.56u as=0.84p ps=3.56u w=3u l=0.55u
X43 VIN.t326 EAOUT.t139 VOUT.t195 VIN.t154 pfet_06v0 ad=0.84p pd=3.56u as=0.84p ps=3.56u w=3u l=0.55u
X44 VIN.t40 EAOUT.t85 VOUT.t17 VIN.t39 pfet_06v0 ad=1.8p pd=7.2u as=0.84p ps=3.56u w=3u l=0.55u
X45 VOUT.t128 EAOUT.t110 VIN.t216 VIN.t118 pfet_06v0 ad=0.84p pd=3.56u as=0.84p ps=3.56u w=3u l=0.55u
X46 VOUT.t94 EAOUT.t194 VIN.t176 VIN.t175 pfet_06v0 ad=0.84p pd=3.56u as=0.84p ps=3.56u w=3u l=0.55u
X47 VOUT.t106 EAOUT.t178 VIN.t191 VIN.t12 pfet_06v0 ad=0.84p pd=3.56u as=0.84p ps=3.56u w=3u l=0.55u
X48 VOUT.t147 EAOUT.t32 VIN.t276 VIN.t193 pfet_06v0 ad=0.84p pd=3.56u as=0.84p ps=3.56u w=3u l=0.55u
X49 VOUT.t131 EAOUT.t16 VIN.t255 VIN.t53 pfet_06v0 ad=0.84p pd=3.56u as=0.84p ps=3.56u w=3u l=0.55u
X50 VOUT.t139 EAOUT.t64 VIN.t268 VIN.t159 pfet_06v0 ad=0.84p pd=3.56u as=0.84p ps=3.56u w=3u l=0.55u
X51 VOUT.t16 EAOUT.t48 VIN.t37 VIN.t36 pfet_06v0 ad=0.84p pd=3.56u as=0.84p ps=3.56u w=3u l=0.55u
X52 VIN.t296 EAOUT.t41 VOUT.t166 VIN.t133 pfet_06v0 ad=0.84p pd=3.56u as=0.84p ps=3.56u w=3u l=0.55u
X53 VSS.t31 VSS.t28 VSS.t30 VSS.t29 nfet_06v0 ad=2.9p pd=11.16u as=0 ps=0 w=5u l=3u
X54 v2_pmos_core.EAREF.t11 VIN.t223 v2_pmos_core.EAREF.t10 VIN.t224 pfet_06v0 ad=0.75p pd=3.7u as=0 ps=0 w=1.25u l=0.55u
X55 a_23576_3894.t10 IREF.t11 VSS.t83 VSS.t82 nfet_05v0 ad=0.35p pd=1.81u as=0.35p ps=1.81u w=1.25u l=0.6u
X56 VIN.t80 a_22144_8265.t3 a_22144_8265.t4 VIN.t79 pfet_06v0 ad=0.7p pd=3.06u as=0.7p ps=3.06u w=2.5u l=3u
X57 VIN.t112 EAOUT.t147 VOUT.t53 VIN.t75 pfet_06v0 ad=0.84p pd=3.56u as=0.84p ps=3.56u w=3u l=0.55u
X58 VOUT.t157 EAOUT.t100 VIN.t286 VIN.t15 pfet_06v0 ad=0.84p pd=3.56u as=0.84p ps=3.56u w=3u l=0.55u
X59 VIN.t123 EAOUT.t93 VOUT.t57 VIN.t122 pfet_06v0 ad=0.84p pd=3.56u as=0.84p ps=3.56u w=3u l=0.55u
X60 VOUT.t23 EAOUT.t60 VIN.t52 VIN.t51 pfet_06v0 ad=0.84p pd=3.56u as=0.84p ps=3.56u w=3u l=0.55u
X61 a_15692_18710# a_14732_8722# VSS.t107 ppolyf_u_1k_6p0 r_width=2u r_length=49.33u
X62 VIN.t190 EAOUT.t177 VOUT.t105 VIN.t189 pfet_06v0 ad=0.84p pd=3.56u as=0.84p ps=3.56u w=3u l=0.55u
X63 VIN.t299 EAOUT.t161 VOUT.t169 VIN.t20 pfet_06v0 ad=0.84p pd=3.56u as=0.84p ps=3.56u w=3u l=0.55u
X64 VIN.t322 EAOUT.t131 VOUT.t191 VIN.t114 pfet_06v0 ad=0.84p pd=3.56u as=0.84p ps=3.56u w=3u l=0.55u
X65 VSS.t64 EN.t0 v2_pmos_core.ENB_5V VSS.t63 nfet_06v0 ad=0.3p pd=2.2u as=0.3p ps=2.2u w=0.5u l=5u
X66 VSS.t19 VSS.t16 VSS.t18 VSS.t17 nfet_05v0 ad=1.45p pd=6.16u as=0 ps=0 w=2.5u l=0.6u
X67 EAOUT.t9 v2_pmos_core.EAREF.t25 a_22144_9605.t13 VIN.t333 pfet_06v0 ad=0.35p pd=1.81u as=0.35p ps=1.81u w=1.25u l=0.55u
X68 VIN.t315 EAOUT.t125 VOUT.t185 VIN.t95 pfet_06v0 ad=0.84p pd=3.56u as=0.84p ps=3.56u w=3u l=0.55u
X69 VIN.t174 EAOUT.t193 VOUT.t93 VIN.t173 pfet_06v0 ad=0.84p pd=3.56u as=0.84p ps=3.56u w=3u l=0.55u
X70 VOUT.t102 EAOUT.t186 VIN.t185 VIN.t45 pfet_06v0 ad=0.84p pd=3.56u as=0.84p ps=3.56u w=3u l=0.55u
X71 VOUT.t118 EAOUT.t166 VIN.t206 VIN.t41 pfet_06v0 ad=0.84p pd=3.56u as=0.84p ps=3.56u w=3u l=0.55u
X72 VIN.t215 EAOUT.t109 VOUT.t127 VIN.t30 pfet_06v0 ad=0.84p pd=3.56u as=0.84p ps=3.56u w=3u l=0.55u
X73 VIN.t60 FB FB_BUF.t1 VSS.t72 nfet_05v0 ad=3p pd=11.2u as=3p ps=11.2u w=5u l=0.6u
X74 VIN.t195 EAOUT.t173 VOUT.t109 VIN.t2 pfet_06v0 ad=0.84p pd=3.56u as=0.84p ps=3.56u w=3u l=0.55u
X75 VOUT.t203 EAOUT.t198 VIN.t337 VIN.t28 pfet_06v0 ad=0.84p pd=3.56u as=0.84p ps=3.56u w=3u l=0.55u
X76 VIN.t161 EAOUT.t205 VOUT.t85 VIN.t98 pfet_06v0 ad=0.84p pd=3.56u as=0.84p ps=3.56u w=3u l=0.55u
X77 VOUT.t64 EAOUT.t182 VIN.t135 VIN.t102 pfet_06v0 ad=0.84p pd=3.56u as=0.84p ps=3.56u w=3u l=0.55u
X78 VOUT.t165 EAOUT.t36 VIN.t295 VIN.t187 pfet_06v0 ad=0.84p pd=3.56u as=0.84p ps=3.56u w=3u l=0.55u
X79 VIN.t302 EAOUT.t75 VOUT.t172 VIN.t109 pfet_06v0 ad=0.84p pd=3.56u as=0.84p ps=3.56u w=3u l=0.55u
X80 VOUT.t47 EAOUT.t68 VIN.t101 VIN.t100 pfet_06v0 ad=0.84p pd=3.56u as=0.84p ps=3.56u w=3u l=0.55u
X81 VOUT.t198 EAOUT.t52 VIN.t331 VIN.t171 pfet_06v0 ad=0.84p pd=3.56u as=0.84p ps=3.56u w=3u l=0.55u
X82 VSS.t3 VSS.t4 VSS.t2 ppolyf_u_1k_6p0 r_width=2u r_length=49.33u
X83 VOUT.t66 EAOUT.t84 VIN.t137 VIN.t129 pfet_06v0 ad=0.84p pd=3.56u as=1.8p ps=7.2u w=3u l=0.55u
X84 VIN.t88 EAOUT.t151 VOUT.t41 VIN.t87 pfet_06v0 ad=0.84p pd=3.56u as=0.84p ps=3.56u w=3u l=0.55u
X85 VOUT.t148 EAOUT.t104 VIN.t277 VIN.t48 pfet_06v0 ad=0.84p pd=3.56u as=0.84p ps=3.56u w=3u l=0.55u
X86 VIN.t310 EAOUT.t97 VOUT.t180 VIN.t4 pfet_06v0 ad=0.84p pd=3.56u as=0.84p ps=3.56u w=3u l=0.55u
X87 v2_pmos_core.EAREF.t13 VIN.t229 v2_pmos_core.EAREF.t12 VIN.t230 pfet_06v0 ad=0.35p pd=1.81u as=0 ps=0 w=1.25u l=0.55u
X88 VSS.t1 IREF.t10 a_23576_3894.t11 VSS.t0 nfet_05v0 ad=0.35p pd=1.81u as=0.35p ps=1.81u w=1.25u l=0.6u
X89 a_15692_18710# a_16652_8722# VSS.t90 ppolyf_u_1k_6p0 r_width=2u r_length=49.33u
X90 VIN.t150 EAOUT.t213 VOUT.t77 VIN.t149 pfet_06v0 ad=0.84p pd=3.56u as=0.84p ps=3.56u w=3u l=0.55u
X91 VIN.t308 EAOUT.t159 VOUT.t178 VIN.t120 pfet_06v0 ad=0.84p pd=3.56u as=0.84p ps=3.56u w=3u l=0.55u
X92 VIN.t320 EAOUT.t129 VOUT.t189 VIN.t319 pfet_06v0 ad=0.84p pd=3.56u as=0.84p ps=3.56u w=3u l=0.55u
X93 VIN.t345 EAOUT.t113 VOUT.t211 VIN.t77 pfet_06v0 ad=0.84p pd=3.56u as=0.84p ps=3.56u w=3u l=0.55u
X94 VOUT.t72 EAOUT.t220 VIN.t144 VIN.t85 pfet_06v0 ad=0.84p pd=3.56u as=0.84p ps=3.56u w=3u l=0.55u
X95 VIN.t336 EAOUT.t197 VOUT.t202 VIN.t105 pfet_06v0 ad=0.84p pd=3.56u as=0.84p ps=3.56u w=3u l=0.55u
X96 EAOUT_BUF.t1 a_644_5248.t9 VSS.t69 VSS.t68 nfet_05v0 ad=1.5p pd=6.2u as=1.5p ps=6.2u w=2.5u l=0.6u
X97 VIN.t155 EAOUT.t209 VOUT.t81 VIN.t154 pfet_06v0 ad=0.84p pd=3.56u as=0.84p ps=3.56u w=3u l=0.55u
X98 VIN.t131 EAOUT.t155 VOUT.t61 VIN.t39 pfet_06v0 ad=1.8p pd=7.2u as=0.84p ps=3.56u w=3u l=0.55u
X99 VOUT.t62 EAOUT.t180 VIN.t132 VIN.t118 pfet_06v0 ad=0.84p pd=3.56u as=0.84p ps=3.56u w=3u l=0.55u
X100 VIN.t249 VIN.t247 VIN.t248 VIN.t236 pfet_06v0 ad=1.45p pd=6.16u as=0 ps=0 w=2.5u l=3u
X101 a_13292_18710# VSS.t96 VSS.t95 ppolyf_u_1k_6p0 r_width=2u r_length=49.33u
X102 VIN.t142 EAOUT.t79 VOUT.t70 VIN.t83 pfet_06v0 ad=0.84p pd=3.56u as=0.84p ps=3.56u w=3u l=0.55u
X103 VOUT.t42 EAOUT.t72 VIN.t90 VIN.t89 pfet_06v0 ad=0.84p pd=3.56u as=0.84p ps=3.56u w=3u l=0.55u
X104 VOUT.t161 EAOUT.t56 VIN.t291 VIN.t290 pfet_06v0 ad=0.84p pd=3.56u as=0.84p ps=3.56u w=3u l=0.55u
X105 a_22144_8265.t2 a_22144_8265.t1 VIN.t66 VIN.t65 pfet_06v0 ad=0.7p pd=3.06u as=0.7p ps=3.06u w=2.5u l=3u
X106 VOUT.t21 EAOUT.t18 VIN.t47 VIN.t8 pfet_06v0 ad=0.84p pd=3.56u as=0.84p ps=3.56u w=3u l=0.55u
X107 VIN.t55 EAOUT.t25 VOUT.t25 VIN.t10 pfet_06v0 ad=0.84p pd=3.56u as=0.84p ps=3.56u w=3u l=0.55u
X108 VOUT.t67 EAOUT.t50 VIN.t139 VIN.t138 pfet_06v0 ad=0.84p pd=3.56u as=0.84p ps=3.56u w=3u l=0.55u
X109 EAOUT.t13 VOUT.t132 cap_mim_2f0_m4m5_noshield c_width=27.35u c_length=54.5u
X110 VIN.t263 v2_pmos_core.ENB_5V VIN_BIAS.t2 VIN.t262 pfet_06v0 ad=3p pd=11.2u as=1.4p ps=5.56u w=5u l=0.6u
X111 VIN.t287 EAOUT.t101 VOUT.t158 VIN.t202 pfet_06v0 ad=0.84p pd=3.56u as=0.84p ps=3.56u w=3u l=0.55u
X112 a_12332_18710# a_12812_8722# VSS.t97 ppolyf_u_1k_6p0 r_width=2u r_length=49.33u
X113 VSS.t34 VSS.t32 VSS.t33 VSS.t21 nfet_06v0 ad=2.9p pd=11.16u as=0 ps=0 w=5u l=3u
X114 a_22144_9605.t4 v2_pmos_core.EAREF.t22 EAOUT.t12 VIN.t97 pfet_06v0 ad=0.35p pd=1.81u as=0.35p ps=1.81u w=1.25u l=0.55u
X115 VIN.t222 VIN.t219 VIN.t221 VIN.t220 pfet_06v0 ad=0.725p pd=3.66u as=0 ps=0 w=1.25u l=0.55u
X116 VIN.t341 EAOUT.t133 VOUT.t207 VIN.t169 pfet_06v0 ad=0.84p pd=3.56u as=0.84p ps=3.56u w=3u l=0.55u
X117 VIN.t210 EAOUT.t217 VOUT.t122 VIN.t75 pfet_06v0 ad=0.84p pd=3.56u as=0.84p ps=3.56u w=3u l=0.55u
X118 VIN.t167 EAOUT.t201 VOUT.t89 VIN.t114 pfet_06v0 ad=0.84p pd=3.56u as=0.84p ps=3.56u w=3u l=0.55u
X119 VOUT.t114 EAOUT.t170 VIN.t201 VIN.t15 pfet_06v0 ad=0.84p pd=3.56u as=0.84p ps=3.56u w=3u l=0.55u
X120 VIN.t301 EAOUT.t163 VOUT.t171 VIN.t122 pfet_06v0 ad=0.84p pd=3.56u as=0.84p ps=3.56u w=3u l=0.55u
X121 VOUT.t143 EAOUT.t140 VIN.t272 VIN.t26 pfet_06v0 ad=0.84p pd=3.56u as=0.84p ps=3.56u w=3u l=0.55u
X122 VIN.t69 EAOUT.t117 VOUT.t32 VIN.t32 pfet_06v0 ad=0.84p pd=3.56u as=0.84p ps=3.56u w=3u l=0.55u
X123 IREF.t5 IREF.t4 VSS.t8 VSS.t7 nfet_05v0 ad=0.35p pd=1.81u as=0.35p ps=1.81u w=1.25u l=0.6u
X124 FB_BUF.t0 a_644_5248.t8 VSS.t71 VSS.t70 nfet_05v0 ad=1.5p pd=6.2u as=1.5p ps=6.2u w=2.5u l=0.6u
X125 VSS.t85 VSS.t86 VSS.t84 ppolyf_u_1k_6p0 r_width=2u r_length=49.33u
X126 VIN.t177 EAOUT.t195 VOUT.t95 VIN.t95 pfet_06v0 ad=0.84p pd=3.56u as=0.84p ps=3.56u w=3u l=0.55u
X127 VIN.t192 EAOUT.t179 VOUT.t107 VIN.t30 pfet_06v0 ad=0.84p pd=3.56u as=0.84p ps=3.56u w=3u l=0.55u
X128 VIN.t313 EAOUT.t71 VOUT.t183 VIN.t157 pfet_06v0 ad=0.84p pd=3.56u as=0.84p ps=3.56u w=3u l=0.55u
X129 VIN.t19 EAOUT.t14 EAOUT_BUF.t0 VSS.t9 nfet_05v0 ad=3p pd=11.2u as=3p ps=11.2u w=5u l=0.6u
X130 VOUT.t43 EAOUT.t76 VIN.t92 VIN.t91 pfet_06v0 ad=0.84p pd=3.56u as=0.84p ps=3.56u w=3u l=0.55u
X131 a_644_5248.t5 v2_pmos_core.ENB_5V VSS.t103 VSS.t102 nfet_05v0 ad=0.6p pd=3.2u as=0.6p ps=3.2u w=1u l=0.6u
X132 VOUT.t164 EAOUT.t22 VIN.t294 VIN.t93 pfet_06v0 ad=0.84p pd=3.56u as=0.84p ps=3.56u w=3u l=0.55u
X133 VIN.t25 EAOUT.t29 VOUT.t10 VIN.t24 pfet_06v0 ad=0.84p pd=3.56u as=0.84p ps=3.56u w=3u l=0.55u
X134 a_22144_8265.t8 a_22144_8265.t7 VIN.t256 VIN.t22 pfet_06v0 ad=0.7p pd=3.06u as=0.7p ps=3.06u w=2.5u l=3u
X135 VOUT.t167 EAOUT.t54 VIN.t297 VIN.t175 pfet_06v0 ad=0.84p pd=3.56u as=0.84p ps=3.56u w=3u l=0.55u
X136 VSS.t101 v2_pmos_core.ENB_5V IREF.t8 VSS.t100 nfet_05v0 ad=0.6p pd=3.2u as=0.6p ps=3.2u w=1u l=0.6u
X137 a_13292_18710# a_14252_8722# VSS.t89 ppolyf_u_1k_6p0 r_width=2u r_length=49.33u
X138 VOUT.t6 EAOUT.t38 VIN.t13 VIN.t12 pfet_06v0 ad=0.84p pd=3.56u as=0.84p ps=3.56u w=3u l=0.55u
X139 VSS.t23 VSS.t20 VSS.t22 VSS.t21 nfet_06v0 ad=2.9p pd=11.16u as=0 ps=0 w=5u l=3u
X140 VOUT.t206 EAOUT.t132 VIN.t340 VIN.t17 pfet_06v0 ad=0.84p pd=3.56u as=0.84p ps=3.56u w=3u l=0.55u
X141 a_644_5248.t3 a_644_5248.t2 VSS.t57 VSS.t56 nfet_05v0 ad=1.5p pd=6.2u as=1.5p ps=6.2u w=2.5u l=0.6u
X142 a_22144_8265.t12 VIN.t250 a_22144_8265.t11 VIN.t240 pfet_06v0 ad=1.5p pd=6.2u as=0 ps=0 w=2.5u l=3u
X143 v2_pmos_core.EAREF.t21 v2_pmos_core.EAREF.t20 a_22144_8265.t10 VIN.t104 pfet_06v0 ad=0.35p pd=1.81u as=0.35p ps=1.81u w=1.25u l=0.55u
X144 a_22144_9605.t7 VIN.t225 v2_pmos_core.EAREF.t8 VIN.t226 pfet_06v0 ad=0.35p pd=1.81u as=0.35p ps=1.81u w=1.25u l=0.55u
X145 VIN_BIAS.t0 a_644_5248.t4 VSS.t77 ppolyf_u_1k_6p0 r_width=1u r_length=1.94384m
X146 VIN.t145 EAOUT.t221 VOUT.t73 VIN.t87 pfet_06v0 ad=0.84p pd=3.56u as=0.84p ps=3.56u w=3u l=0.55u
X147 VIN.t207 EAOUT.t167 VOUT.t119 VIN.t4 pfet_06v0 ad=0.84p pd=3.56u as=0.84p ps=3.56u w=3u l=0.55u
X148 VOUT.t50 EAOUT.t144 VIN.t108 VIN.t107 pfet_06v0 ad=0.84p pd=3.56u as=0.84p ps=3.56u w=3u l=0.55u
X149 VIN.t324 EAOUT.t137 VOUT.t193 VIN.t164 pfet_06v0 ad=0.84p pd=3.56u as=0.84p ps=3.56u w=3u l=0.55u
X150 VIN.t282 EAOUT.t121 VOUT.t153 VIN.t73 pfet_06v0 ad=0.84p pd=3.56u as=0.84p ps=3.56u w=3u l=0.55u
X151 VOUT.t0 EAOUT.t90 VIN.t1 VIN.t0 pfet_06v0 ad=0.84p pd=3.56u as=0.84p ps=3.56u w=3u l=0.55u
X152 v2_pmos_core.EAREF.t7 FB a_23576_3894.t5 VSS.t59 nfet_06v0 ad=1.4p pd=5.56u as=1.4p ps=5.56u w=5u l=3u
X153 VOUT.t110 EAOUT.t174 VIN.t196 VIN.t48 pfet_06v0 ad=0.84p pd=3.56u as=0.84p ps=3.56u w=3u l=0.55u
X154 VIN.t347 EAOUT.t115 VOUT.t213 VIN.t183 pfet_06v0 ad=0.84p pd=3.56u as=0.84p ps=3.56u w=3u l=0.55u
X155 VIN.t338 EAOUT.t199 VOUT.t204 VIN.t319 pfet_06v0 ad=0.84p pd=3.56u as=0.84p ps=3.56u w=3u l=0.55u
X156 VIN.t136 EAOUT.t183 VOUT.t65 VIN.t77 pfet_06v0 ad=0.84p pd=3.56u as=0.84p ps=3.56u w=3u l=0.55u
X157 VIN.t128 EAOUT.t153 VOUT.t59 VIN.t127 pfet_06v0 ad=0.84p pd=3.56u as=0.84p ps=3.56u w=3u l=0.55u
X158 VIN.t332 EAOUT.t37 VOUT.t199 VIN.t189 pfet_06v0 ad=0.84p pd=3.56u as=0.84p ps=3.56u w=3u l=0.55u
X159 v2_pmos_core.EAREF.t1 VSS.t35 v2_pmos_core.EAREF.t0 VSS.t25 nfet_06v0 ad=3p pd=11.2u as=0 ps=0 w=5u l=3u
X160 a_22144_9605.t11 VIN.t241 a_22144_9605.t10 VIN.t242 pfet_06v0 ad=0.7p pd=3.06u as=0 ps=0 w=2.5u l=3u
X161 VIN.t21 EAOUT.t21 VOUT.t9 VIN.t20 pfet_06v0 ad=0.84p pd=3.56u as=0.84p ps=3.56u w=3u l=0.55u
X162 VOUT.t20 EAOUT.t46 VIN.t46 VIN.t45 pfet_06v0 ad=0.84p pd=3.56u as=0.84p ps=3.56u w=3u l=0.55u
X163 VIN.t334 EAOUT.t53 VOUT.t200 VIN.t173 pfet_06v0 ad=0.84p pd=3.56u as=0.84p ps=3.56u w=3u l=0.55u
X164 VIN.t3 EAOUT.t33 VOUT.t1 VIN.t2 pfet_06v0 ad=0.84p pd=3.56u as=0.84p ps=3.56u w=3u l=0.55u
X165 VSS.t6 IREF.t2 IREF.t3 VSS.t5 nfet_05v0 ad=0.35p pd=1.81u as=0.35p ps=1.81u w=1.25u l=0.6u
X166 VIN.t35 a_22144_8265.t19 a_22144_9605.t1 VIN.t34 pfet_06v0 ad=0.7p pd=3.06u as=0.7p ps=3.06u w=2.5u l=3u
X167 VOUT.t18 EAOUT.t26 VIN.t42 VIN.t41 pfet_06v0 ad=0.84p pd=3.56u as=0.84p ps=3.56u w=3u l=0.55u
X168 VIN.t99 EAOUT.t65 VOUT.t46 VIN.t98 pfet_06v0 ad=0.84p pd=3.56u as=0.84p ps=3.56u w=3u l=0.55u
X169 VOUT.t13 EAOUT.t58 VIN.t29 VIN.t28 pfet_06v0 ad=0.84p pd=3.56u as=0.84p ps=3.56u w=3u l=0.55u
X170 VOUT.t48 EAOUT.t42 VIN.t103 VIN.t102 pfet_06v0 ad=0.84p pd=3.56u as=0.84p ps=3.56u w=3u l=0.55u
X171 VIN.t265 v2_pmos_core.ENB_5V v2_pmos_core.EN_5V.t1 VIN.t264 pfet_06v0 ad=3p pd=11.2u as=3p ps=11.2u w=5u l=0.6u
X172 VOUT.t58 EAOUT.t152 VIN.t126 VIN.t125 pfet_06v0 ad=0.84p pd=3.56u as=0.84p ps=3.56u w=3u l=0.55u
X173 VOUT.t192 EAOUT.t136 VIN.t323 VIN.t162 pfet_06v0 ad=0.84p pd=3.56u as=0.84p ps=3.56u w=3u l=0.55u
X174 VIN.t278 EAOUT.t105 VOUT.t149 VIN.t197 pfet_06v0 ad=0.84p pd=3.56u as=0.84p ps=3.56u w=3u l=0.55u
X175 VOUT.t181 EAOUT.t98 VIN.t311 VIN.t61 pfet_06v0 ad=0.84p pd=3.56u as=0.84p ps=3.56u w=3u l=0.55u
X176 a_15212_18710# a_14252_8722# VSS.t79 ppolyf_u_1k_6p0 r_width=2u r_length=49.33u
X177 EAOUT.t6 VREF.t2 a_23576_3894.t1 VSS.t59 nfet_06v0 ad=1.4p pd=5.56u as=1.4p ps=5.56u w=5u l=3u
X178 VOUT.t212 EAOUT.t114 VIN.t346 VIN.t63 pfet_06v0 ad=0.84p pd=3.56u as=0.84p ps=3.56u w=3u l=0.55u
X179 VIN.t59 EAOUT.t87 VOUT.t28 VIN.t58 pfet_06v0 ad=0.84p pd=3.56u as=0.84p ps=3.56u w=3u l=0.55u
X180 VSS.t47 VSS.t44 VSS.t46 VSS.t45 nfet_05v0 ad=0.75p pd=3.7u as=0 ps=0 w=1.25u l=0.6u
X181 VIN.t203 EAOUT.t171 VOUT.t115 VIN.t202 pfet_06v0 ad=0.84p pd=3.56u as=0.84p ps=3.56u w=3u l=0.55u
X182 VOUT.t38 EAOUT.t148 VIN.t82 VIN.t6 pfet_06v0 ad=0.84p pd=3.56u as=0.84p ps=3.56u w=3u l=0.55u
X183 VOUT.t26 EAOUT.t94 VIN.t56 VIN.t43 pfet_06v0 ad=0.84p pd=3.56u as=0.84p ps=3.56u w=3u l=0.55u
X184 EAOUT.t2 VSS.t24 EAOUT.t1 VSS.t25 nfet_06v0 ad=3p pd=11.2u as=0 ps=0 w=5u l=3u
X185 VOUT.t82 EAOUT.t210 VIN.t156 VIN.t26 pfet_06v0 ad=0.84p pd=3.56u as=0.84p ps=3.56u w=3u l=0.55u
X186 VIN.t170 EAOUT.t203 VOUT.t91 VIN.t169 pfet_06v0 ad=0.84p pd=3.56u as=0.84p ps=3.56u w=3u l=0.55u
X187 VIN.t72 EAOUT.t119 VOUT.t34 VIN.t71 pfet_06v0 ad=0.84p pd=3.56u as=0.84p ps=3.56u w=3u l=0.55u
X188 VIN.t186 EAOUT.t187 VOUT.t103 VIN.t32 pfet_06v0 ad=0.84p pd=3.56u as=0.84p ps=3.56u w=3u l=0.55u
X189 VOUT.t196 EAOUT.t80 VIN.t327 VIN.t85 pfet_06v0 ad=0.84p pd=3.56u as=0.84p ps=3.56u w=3u l=0.55u
X190 VIN.t330 EAOUT.t73 VOUT.t197 VIN.t149 pfet_06v0 ad=0.84p pd=3.56u as=0.84p ps=3.56u w=3u l=0.55u
X191 VIN.t106 EAOUT.t57 VOUT.t49 VIN.t105 pfet_06v0 ad=0.84p pd=3.56u as=0.84p ps=3.56u w=3u l=0.55u
X192 VIN.t124 a_22144_8265.t16 a_22144_9605.t6 VIN.t79 pfet_06v0 ad=0.7p pd=3.06u as=0.7p ps=3.06u w=2.5u l=3u
X193 VIN.t329 v2_pmos_core.EN_5V.t2 EAOUT.t0 VIN.t328 pfet_06v0 ad=3p pd=11.2u as=3p ps=11.2u w=5u l=0.6u
X194 VIN.t292 EAOUT.t19 VOUT.t162 VIN.t120 pfet_06v0 ad=0.84p pd=3.56u as=0.84p ps=3.56u w=3u l=0.55u
X195 VIN.t246 VIN.t243 VIN.t245 VIN.t244 pfet_06v0 ad=1.45p pd=6.16u as=0 ps=0 w=2.5u l=3u
X196 a_23576_3894.t8 IREF.t13 VSS.t67 VSS.t66 nfet_05v0 ad=0.35p pd=1.81u as=0.35p ps=1.81u w=1.25u l=0.6u
X197 VOUT.t159 EAOUT.t102 VIN.t288 VIN.t193 pfet_06v0 ad=0.84p pd=3.56u as=0.84p ps=3.56u w=3u l=0.55u
X198 VIN.t270 EAOUT.t69 VOUT.t141 VIN.t154 pfet_06v0 ad=0.84p pd=3.56u as=0.84p ps=3.56u w=3u l=0.55u
X199 VIN.t293 EAOUT.t15 VOUT.t163 VIN.t39 pfet_06v0 ad=1.8p pd=7.2u as=0.84p ps=3.56u w=3u l=0.55u
X200 VOUT.t24 EAOUT.t86 VIN.t54 VIN.t53 pfet_06v0 ad=0.84p pd=3.56u as=0.84p ps=3.56u w=3u l=0.55u
X201 a_644_5248.t1 a_644_5248.t0 VSS.t11 VSS.t10 nfet_05v0 ad=1.5p pd=6.2u as=1.5p ps=6.2u w=2.5u l=0.6u
X202 EAOUT.t11 v2_pmos_core.EAREF.t23 a_22144_9605.t2 VIN.t50 pfet_06v0 ad=0.35p pd=1.81u as=0.35p ps=1.81u w=1.25u l=0.55u
X203 VOUT.t208 EAOUT.t134 VIN.t342 VIN.t159 pfet_06v0 ad=0.84p pd=3.56u as=0.84p ps=3.56u w=3u l=0.55u
X204 VOUT.t55 EAOUT.t40 VIN.t119 VIN.t118 pfet_06v0 ad=0.84p pd=3.56u as=0.84p ps=3.56u w=3u l=0.55u
X205 VSS.t105 v2_pmos_core.ENB_5V VOUT.t136 VSS.t104 nfet_05v0 ad=3p pd=11.2u as=3p ps=11.2u w=5u l=0.6u
X206 a_23576_3894.t2 VREF.t0 EAOUT.t8 VSS.t61 nfet_06v0 ad=1.4p pd=5.56u as=1.4p ps=5.56u w=5u l=3u
X207 VOUT.t90 EAOUT.t202 VIN.t168 VIN.t17 pfet_06v0 ad=0.84p pd=3.56u as=0.84p ps=3.56u w=3u l=0.55u
X208 VOUT.t33 EAOUT.t118 VIN.t70 VIN.t36 pfet_06v0 ad=0.84p pd=3.56u as=0.84p ps=3.56u w=3u l=0.55u
X209 VIN.t217 EAOUT.t111 VOUT.t129 VIN.t133 pfet_06v0 ad=0.84p pd=3.56u as=0.84p ps=3.56u w=3u l=0.55u
X210 a_22144_8265.t9 v2_pmos_core.EAREF.t14 v2_pmos_core.EAREF.t15 VIN.t81 pfet_06v0 ad=0.35p pd=1.81u as=0.35p ps=1.81u w=1.25u l=0.55u
X211 VOUT.t190 EAOUT.t130 VIN.t321 VIN.t51 pfet_06v0 ad=0.84p pd=3.56u as=0.84p ps=3.56u w=3u l=0.55u
X212 IREF.t1 IREF.t0 VSS.t81 VSS.t80 nfet_05v0 ad=0.35p pd=1.81u as=0.35p ps=1.81u w=1.25u l=0.6u
X213 VOUT.t78 EAOUT.t214 VIN.t151 VIN.t107 pfet_06v0 ad=0.84p pd=3.56u as=0.84p ps=3.56u w=3u l=0.55u
X214 VIN.t165 EAOUT.t207 VOUT.t87 VIN.t164 pfet_06v0 ad=0.84p pd=3.56u as=0.84p ps=3.56u w=3u l=0.55u
X215 VIN.t181 EAOUT.t191 VOUT.t99 VIN.t73 pfet_06v0 ad=0.84p pd=3.56u as=0.84p ps=3.56u w=3u l=0.55u
X216 VOUT.t168 EAOUT.t160 VIN.t298 VIN.t0 pfet_06v0 ad=0.84p pd=3.56u as=0.84p ps=3.56u w=3u l=0.55u
X217 VSS.t51 VSS.t48 VSS.t50 VSS.t49 nfet_05v0 ad=0.35p pd=1.81u as=0 ps=0 w=1.25u l=0.6u
X218 VIN.t147 EAOUT.t223 VOUT.t75 VIN.t127 pfet_06v0 ad=0.84p pd=3.56u as=0.84p ps=3.56u w=3u l=0.55u
X219 VIN.t184 EAOUT.t185 VOUT.t101 VIN.t183 pfet_06v0 ad=0.84p pd=3.56u as=0.84p ps=3.56u w=3u l=0.55u
X220 VIN.t76 EAOUT.t77 VOUT.t36 VIN.t75 pfet_06v0 ad=0.84p pd=3.56u as=0.84p ps=3.56u w=3u l=0.55u
X221 VIN.t213 EAOUT.t23 VOUT.t125 VIN.t122 pfet_06v0 ad=0.84p pd=3.56u as=0.84p ps=3.56u w=3u l=0.55u
X222 VIN.t115 EAOUT.t61 VOUT.t54 VIN.t114 pfet_06v0 ad=0.84p pd=3.56u as=0.84p ps=3.56u w=3u l=0.55u
X223 VOUT.t7 EAOUT.t30 VIN.t16 VIN.t15 pfet_06v0 ad=0.84p pd=3.56u as=0.84p ps=3.56u w=3u l=0.55u
X224 VIN.t96 EAOUT.t55 VOUT.t45 VIN.t95 pfet_06v0 ad=0.84p pd=3.56u as=0.84p ps=3.56u w=3u l=0.55u
X225 VIN.t31 EAOUT.t39 VOUT.t14 VIN.t30 pfet_06v0 ad=0.84p pd=3.56u as=0.84p ps=3.56u w=3u l=0.55u
X226 a_13772_18710# a_12812_8722# VSS.t73 ppolyf_u_1k_6p0 r_width=2u r_length=49.33u
X227 VOUT.t150 EAOUT.t106 VIN.t279 VIN.t187 pfet_06v0 ad=0.84p pd=3.56u as=0.84p ps=3.56u w=3u l=0.55u
X228 a_23576_3894.t6 FB v2_pmos_core.EAREF.t5 VSS.t61 nfet_06v0 ad=1.4p pd=5.56u as=1.4p ps=5.56u w=5u l=3u
X229 FB_BUF.t2 a_644_5248.t7 VSS.t88 VSS.t87 nfet_05v0 ad=1.5p pd=6.2u as=1.5p ps=6.2u w=2.5u l=0.6u
X230 a_22144_8265.t15 v2_pmos_core.EAREF.t18 v2_pmos_core.EAREF.t19 VIN.t258 pfet_06v0 ad=0.35p pd=1.81u as=0.35p ps=1.81u w=1.25u l=0.55u
X231 v2_pmos_core.EAREF.t17 v2_pmos_core.EAREF.t16 a_22144_8265.t0 VIN.t14 pfet_06v0 ad=0.35p pd=1.81u as=0.35p ps=1.81u w=1.25u l=0.55u
X232 VOUT.t74 EAOUT.t222 VIN.t146 VIN.t125 pfet_06v0 ad=0.84p pd=3.56u as=0.84p ps=3.56u w=3u l=0.55u
X233 VOUT.t112 EAOUT.t168 VIN.t199 VIN.t61 pfet_06v0 ad=0.84p pd=3.56u as=0.84p ps=3.56u w=3u l=0.55u
X234 VIN.t110 EAOUT.t145 VOUT.t51 VIN.t109 pfet_06v0 ad=0.84p pd=3.56u as=0.84p ps=3.56u w=3u l=0.55u
X235 VOUT.t194 EAOUT.t138 VIN.t325 VIN.t100 pfet_06v0 ad=0.84p pd=3.56u as=0.84p ps=3.56u w=3u l=0.55u
X236 VOUT.t154 EAOUT.t122 VIN.t283 VIN.t171 pfet_06v0 ad=0.84p pd=3.56u as=0.84p ps=3.56u w=3u l=0.55u
X237 VOUT.t86 EAOUT.t206 VIN.t163 VIN.t162 pfet_06v0 ad=0.84p pd=3.56u as=0.84p ps=3.56u w=3u l=0.55u
X238 VIN.t198 EAOUT.t175 VOUT.t111 VIN.t197 pfet_06v0 ad=0.84p pd=3.56u as=0.84p ps=3.56u w=3u l=0.55u
X239 VOUT.t123 EAOUT.t218 VIN.t211 VIN.t6 pfet_06v0 ad=0.84p pd=3.56u as=0.84p ps=3.56u w=3u l=0.55u
X240 VOUT.t100 EAOUT.t184 VIN.t182 VIN.t63 pfet_06v0 ad=0.84p pd=3.56u as=0.84p ps=3.56u w=3u l=0.55u
X241 VOUT.t116 EAOUT.t164 VIN.t204 VIN.t43 pfet_06v0 ad=0.84p pd=3.56u as=0.84p ps=3.56u w=3u l=0.55u
X242 VIN.t306 EAOUT.t157 VOUT.t176 VIN.t58 pfet_06v0 ad=0.84p pd=3.56u as=0.84p ps=3.56u w=3u l=0.55u
X243 VOUT.t60 EAOUT.t154 VIN.t130 VIN.t129 pfet_06v0 ad=0.84p pd=3.56u as=1.8p ps=7.2u w=3u l=0.55u
X244 a_22144_9605.t3 a_22144_8265.t17 VIN.t67 VIN.t65 pfet_06v0 ad=0.7p pd=3.06u as=0.7p ps=3.06u w=2.5u l=3u
X245 VIN.t179 EAOUT.t189 VOUT.t97 VIN.t71 pfet_06v0 ad=0.84p pd=3.56u as=0.84p ps=3.56u w=3u l=0.55u
X246 VIN.t304 EAOUT.t81 VOUT.t174 VIN.t87 pfet_06v0 ad=0.84p pd=3.56u as=0.84p ps=3.56u w=3u l=0.55u
X247 VOUT.t22 EAOUT.t34 VIN.t49 VIN.t48 pfet_06v0 ad=0.84p pd=3.56u as=0.84p ps=3.56u w=3u l=0.55u
X248 VIN.t5 EAOUT.t27 VOUT.t2 VIN.t4 pfet_06v0 ad=0.84p pd=3.56u as=0.84p ps=3.56u w=3u l=0.55u
X249 EAOUT_BUF.t2 a_644_5248.t6 VSS.t94 VSS.t93 nfet_05v0 ad=1.5p pd=6.2u as=1.5p ps=6.2u w=2.5u l=0.6u
X250 VIN.t339 EAOUT.t59 VOUT.t205 VIN.t319 pfet_06v0 ad=0.84p pd=3.56u as=0.84p ps=3.56u w=3u l=0.55u
X251 VIN.t78 EAOUT.t43 VOUT.t37 VIN.t77 pfet_06v0 ad=0.84p pd=3.56u as=0.84p ps=3.56u w=3u l=0.55u
X252 EAOUT.t7 VREF.t1 a_23576_3894.t0 VSS.t60 nfet_06v0 ad=1.4p pd=5.56u as=1.4p ps=5.56u w=5u l=3u
X253 a_22144_9605.t5 v2_pmos_core.EAREF.t24 EAOUT.t10 VIN.t113 pfet_06v0 ad=0.35p pd=1.81u as=0.35p ps=1.81u w=1.25u l=0.55u
X254 VSS.t43 VSS.t40 VSS.t42 VSS.t41 nfet_05v0 ad=0.725p pd=3.66u as=0 ps=0 w=1.25u l=0.6u
X255 a_13772_18710# a_14732_8722# VSS.t76 ppolyf_u_1k_6p0 r_width=2u r_length=49.33u
X256 VOUT.t108 EAOUT.t172 VIN.t194 VIN.t193 pfet_06v0 ad=0.84p pd=3.56u as=0.84p ps=3.56u w=3u l=0.55u
X257 VOUT.t175 EAOUT.t156 VIN.t305 VIN.t53 pfet_06v0 ad=0.84p pd=3.56u as=0.84p ps=3.56u w=3u l=0.55u
X258 VIN.t84 EAOUT.t149 VOUT.t39 VIN.t83 pfet_06v0 ad=0.84p pd=3.56u as=0.84p ps=3.56u w=3u l=0.55u
X259 VOUT.t145 EAOUT.t142 VIN.t274 VIN.t89 pfet_06v0 ad=0.84p pd=3.56u as=0.84p ps=3.56u w=3u l=0.55u
X260 VOUT.t186 EAOUT.t126 VIN.t316 VIN.t290 pfet_06v0 ad=0.84p pd=3.56u as=0.84p ps=3.56u w=3u l=0.55u
X261 VIN.t11 EAOUT.t95 VOUT.t5 VIN.t10 pfet_06v0 ad=0.84p pd=3.56u as=0.84p ps=3.56u w=3u l=0.55u
X262 VOUT.t4 EAOUT.t88 VIN.t9 VIN.t8 pfet_06v0 ad=0.84p pd=3.56u as=0.84p ps=3.56u w=3u l=0.55u
X263 VSS.t75 IREF.t6 IREF.t7 VSS.t74 nfet_05v0 ad=0.35p pd=1.81u as=0.35p ps=1.81u w=1.25u l=0.6u
X264 VIN.t117 VSS.t108 v2_pmos_core.ENB_5V VIN.t116 pfet_06v0 ad=0.6p pd=3.2u as=0.6p ps=3.2u w=1u l=40u
X265 VOUT.t84 EAOUT.t204 VIN.t160 VIN.t159 pfet_06v0 ad=0.84p pd=3.56u as=0.84p ps=3.56u w=3u l=0.55u
X266 VIN.t134 EAOUT.t181 VOUT.t63 VIN.t133 pfet_06v0 ad=0.84p pd=3.56u as=0.84p ps=3.56u w=3u l=0.55u
X267 VOUT.t152 EAOUT.t120 VIN.t281 VIN.t138 pfet_06v0 ad=0.84p pd=3.56u as=0.84p ps=3.56u w=3u l=0.55u
X268 VOUT.t96 EAOUT.t188 VIN.t178 VIN.t36 pfet_06v0 ad=0.84p pd=3.56u as=0.84p ps=3.56u w=3u l=0.55u
X269 VOUT.t88 EAOUT.t200 VIN.t166 VIN.t51 pfet_06v0 ad=0.84p pd=3.56u as=0.84p ps=3.56u w=3u l=0.55u
X270 VIN.t208 EAOUT.t31 VOUT.t120 VIN.t202 pfet_06v0 ad=0.84p pd=3.56u as=0.84p ps=3.56u w=3u l=0.55u
X271 VIN_BIAS.t3 IREF.t9 VSS.t106 ppolyf_u_1k_6p0 r_width=1u r_length=0.19609m
X272 v2_pmos_core.EAREF.t4 FB a_23576_3894.t7 VSS.t60 nfet_06v0 ad=1.4p pd=5.56u as=1.4p ps=5.56u w=5u l=3u
X273 VOUT.t11 EAOUT.t70 VIN.t27 VIN.t26 pfet_06v0 ad=0.84p pd=3.56u as=0.84p ps=3.56u w=3u l=0.55u
X274 VIN.t269 EAOUT.t63 VOUT.t140 VIN.t169 pfet_06v0 ad=0.84p pd=3.56u as=0.84p ps=3.56u w=3u l=0.55u
X275 VIN.t33 EAOUT.t47 VOUT.t15 VIN.t32 pfet_06v0 ad=0.84p pd=3.56u as=0.84p ps=3.56u w=3u l=0.55u
X276 VIN.t273 EAOUT.t141 VOUT.t144 VIN.t157 pfet_06v0 ad=0.84p pd=3.56u as=0.84p ps=3.56u w=3u l=0.55u
X277 VSS.t15 VSS.t12 VSS.t14 VSS.t13 nfet_05v0 ad=1.45p pd=6.16u as=0 ps=0 w=2.5u l=0.6u
X278 a_15212_18710# FB VSS.t62 ppolyf_u_1k_6p0 r_width=2u r_length=49.33u
X279 VIN.t238 VIN.t235 VIN.t237 VIN.t236 pfet_06v0 ad=1.45p pd=6.16u as=0 ps=0 w=2.5u l=3u
X280 VOUT.t52 EAOUT.t146 VIN.t111 VIN.t91 pfet_06v0 ad=0.84p pd=3.56u as=0.84p ps=3.56u w=3u l=0.55u
X281 VIN.t312 EAOUT.t99 VOUT.t182 VIN.t24 pfet_06v0 ad=0.84p pd=3.56u as=0.84p ps=3.56u w=3u l=0.55u
X282 VOUT.t44 EAOUT.t92 VIN.t94 VIN.t93 pfet_06v0 ad=0.84p pd=3.56u as=0.84p ps=3.56u w=3u l=0.55u
X283 VOUT.t104 EAOUT.t176 VIN.t188 VIN.t187 pfet_06v0 ad=0.84p pd=3.56u as=0.84p ps=3.56u w=3u l=0.55u
X284 a_22144_8265.t14 VIN.t251 a_22144_8265.t13 VIN.t242 pfet_06v0 ad=0.7p pd=3.06u as=0 ps=0 w=2.5u l=3u
X285 VOUT.t184 EAOUT.t124 VIN.t314 VIN.t175 pfet_06v0 ad=0.84p pd=3.56u as=0.84p ps=3.56u w=3u l=0.55u
X286 VIN.t152 EAOUT.t215 VOUT.t79 VIN.t109 pfet_06v0 ad=0.84p pd=3.56u as=0.84p ps=3.56u w=3u l=0.55u
X287 VOUT.t80 EAOUT.t208 VIN.t153 VIN.t100 pfet_06v0 ad=0.84p pd=3.56u as=0.84p ps=3.56u w=3u l=0.55u
X288 VOUT.t92 EAOUT.t192 VIN.t172 VIN.t171 pfet_06v0 ad=0.84p pd=3.56u as=0.84p ps=3.56u w=3u l=0.55u
X289 VOUT.t126 EAOUT.t108 VIN.t214 VIN.t12 pfet_06v0 ad=0.84p pd=3.56u as=0.84p ps=3.56u w=3u l=0.55u
X290 VIN.t38 a_22144_8265.t5 a_22144_8265.t6 VIN.t34 pfet_06v0 ad=0.7p pd=3.06u as=0.7p ps=3.06u w=2.5u l=3u
X291 VOUT.t71 EAOUT.t224 VIN.t143 VIN.t129 pfet_06v0 ad=0.84p pd=3.56u as=1.8p ps=7.2u w=3u l=0.55u
X292 VSS.t99 v2_pmos_core.ENB_5V v2_pmos_core.EN_5V.t0 VSS.t98 nfet_05v0 ad=3p pd=11.2u as=3p ps=11.2u w=5u l=0.6u
X293 VOUT.t8 EAOUT.t62 VIN.t18 VIN.t17 pfet_06v0 ad=0.84p pd=3.56u as=0.84p ps=3.56u w=3u l=0.55u
X294 v2_pmos_core.EAREF.t3 VSS.t36 v2_pmos_core.EAREF.t2 VSS.t27 nfet_06v0 ad=1.4p pd=5.56u as=0 ps=0 w=5u l=3u
X295 VOUT.t137 EAOUT.t74 VIN.t266 VIN.t107 pfet_06v0 ad=0.84p pd=3.56u as=0.84p ps=3.56u w=3u l=0.55u
X296 VIN.t285 EAOUT.t67 VOUT.t156 VIN.t164 pfet_06v0 ad=0.84p pd=3.56u as=0.84p ps=3.56u w=3u l=0.55u
X297 a_23576_3894.t4 FB v2_pmos_core.EAREF.t6 VSS.t58 nfet_06v0 ad=1.4p pd=5.56u as=1.4p ps=5.56u w=5u l=3u
X298 VIN_BIAS.t1 v2_pmos_core.ENB_5V VIN.t261 VIN.t260 pfet_06v0 ad=1.4p pd=5.56u as=3p ps=11.2u w=5u l=0.6u
X299 VOUT.t27 EAOUT.t20 VIN.t57 VIN.t0 pfet_06v0 ad=0.84p pd=3.56u as=0.84p ps=3.56u w=3u l=0.55u
X300 a_12332_18710# FB VSS.t78 ppolyf_u_1k_6p0 r_width=2u r_length=49.33u
X301 VIN.t280 EAOUT.t107 VOUT.t151 VIN.t189 pfet_06v0 ad=0.84p pd=3.56u as=0.84p ps=3.56u w=3u l=0.55u
X302 VIN.t218 EAOUT.t91 VOUT.t130 VIN.t20 pfet_06v0 ad=0.84p pd=3.56u as=0.84p ps=3.56u w=3u l=0.55u
X303 VIN.t74 EAOUT.t51 VOUT.t35 VIN.t73 pfet_06v0 ad=0.84p pd=3.56u as=0.84p ps=3.56u w=3u l=0.55u
C0 v2_pmos_core.ENB_5V EN 0.45365f
C1 EAOUT FB 2.46299f
C2 a_16652_8722# a_14252_8722# 0.00328f
C3 VIN_BIAS VIN 3.5043f
C4 a_13292_18710# a_13772_18710# 0.55839f
C5 a_15692_18710# a_15212_18710# 0.55839f
C6 FB a_12812_8722# 0.09449f
C7 VIN VOUT 0.22154p
C8 a_12332_18710# a_13292_18710# 0.10341f
C9 v2_pmos_core.EN_5V EN 0
C10 a_16652_8722# FB 0.09449f
C11 VIN_BIAS VOUT 1.06282f
C12 a_16652_8722# EAOUT 0.00551f
C13 v2_pmos_core.ENB_5V VIN 5.84222f
C14 a_15692_18710# a_13772_18710# 0.01219f
C15 IREF FB 1.17364f
C16 v2_pmos_core.EAREF FB 1.60229f
C17 FB FB_BUF 0.13171f
C18 v2_pmos_core.ENB_5V VIN_BIAS 0.32214f
C19 EAOUT IREF 0
C20 FB EAOUT_BUF 0.00117f
C21 v2_pmos_core.EN_5V VIN 5.49317f
C22 EAOUT v2_pmos_core.EAREF 0.83276f
C23 VIN VREF 1.86855f
C24 v2_pmos_core.ENB_5V VOUT 0.21116f
C25 EAOUT EAOUT_BUF 0.13173f
C26 v2_pmos_core.EN_5V VIN_BIAS 0.21628f
C27 VIN_BIAS VREF 0.56562f
C28 v2_pmos_core.EN_5V VOUT 0.00126f
C29 VOUT VREF 6.6445f
C30 FB EN 0.00702f
C31 v2_pmos_core.ENB_5V v2_pmos_core.EN_5V 7.6458f
C32 v2_pmos_core.ENB_5V VREF 0
C33 EAOUT_BUF FB_BUF 3.16535f
C34 v2_pmos_core.EN_5V VREF 0.09237f
C35 a_15212_18710# VOUT 0
C36 FB VIN 0.12777f
C37 EAOUT VIN 0.1111p
C38 VIN_BIAS FB 4.33507f
C39 IREF EN 0.52473f
C40 EAOUT VIN_BIAS 3.26767f
C41 a_16652_8722# VIN 0
C42 EAOUT VOUT 52.2522f
C43 v2_pmos_core.ENB_5V FB 1.29441f
C44 v2_pmos_core.EAREF VIN 7.48966f
C45 VIN FB_BUF 1.3355f
C46 EAOUT v2_pmos_core.ENB_5V 6.84284f
C47 VIN EAOUT_BUF 1.73917f
C48 v2_pmos_core.EN_5V FB 0.13954f
C49 IREF VIN_BIAS 2.64893f
C50 v2_pmos_core.EAREF VIN_BIAS 0.00359f
C51 FB VREF 3.37218f
C52 EAOUT v2_pmos_core.EN_5V 1.77002f
C53 VIN_BIAS EAOUT_BUF 0.01287f
C54 EAOUT VREF 6.43736f
C55 a_15692_18710# VOUT 0.10952f
C56 IREF VOUT 0.00178f
C57 a_14252_8722# a_14732_8722# 0.55839f
C58 v2_pmos_core.ENB_5V IREF 6.00996f
C59 v2_pmos_core.ENB_5V v2_pmos_core.EAREF 0.01808f
C60 v2_pmos_core.ENB_5V FB_BUF 0.0069f
C61 a_13772_18710# a_15212_18710# 0.09449f
C62 v2_pmos_core.ENB_5V EAOUT_BUF 0.00483f
C63 FB a_14732_8722# 0.10952f
C64 VIN_BIAS EN 0.06445f
C65 v2_pmos_core.EN_5V IREF 0.09314f
C66 v2_pmos_core.EAREF v2_pmos_core.EN_5V 7.58439f
C67 a_13292_18710# a_15212_18710# 0.00488f
C68 IREF VREF 0.00653f
C69 v2_pmos_core.EAREF VREF 0.18625f
C70 FB a_14252_8722# 0
C71 a_16652_8722# a_14732_8722# 0
C72 a_12812_8722# a_14252_8722# 0.10341f
R0 EN EN.t0 26.5424
R1 VREF VREF.n1 29.4554
R2 VREF.n1 VREF.n2 16.3252
R3 VREF.n2 VREF.t0 17.2228
R4 VREF.n2 VREF.t1 17.9194
R5 VREF.n1 VREF.n0 12.6083
R6 VREF.n0 VREF.t2 17.2228
R7 VREF.n0 VREF.t3 19.3124
R8 FB_BUF FB_BUF.n1 3.02734
R9 FB_BUF.n1 FB_BUF.t1 21.9136
R10 FB_BUF.n1 FB_BUF.n0 10.0572
R11 FB_BUF.n0 FB_BUF.t2 8.62357
R12 FB_BUF.n0 FB_BUF.t0 8.16637
R13 EAOUT_BUF EAOUT_BUF.n1 1.72945
R14 EAOUT_BUF.n1 EAOUT_BUF.t0 24.4573
R15 EAOUT_BUF.n1 EAOUT_BUF.n0 10.4726
R16 EAOUT_BUF.n0 EAOUT_BUF.t2 10.0317
R17 EAOUT_BUF.n0 EAOUT_BUF.t1 7.74572
R18 VOUT.n0 VOUT 4.5005
R19 VOUT.n2 VOUT.n1 0.0431667
R20 VOUT.n3 VOUT.n2 0.0431667
R21 VOUT.n4 VOUT.n3 0.0431667
R22 VOUT.n5 VOUT.n4 0.0431667
R23 VOUT.n6 VOUT.n5 0.0431667
R24 VOUT.n7 VOUT.n6 0.0431667
R25 VOUT.n8 VOUT.n7 0.0431667
R26 VOUT.n9 VOUT.n8 0.0431667
R27 VOUT.n10 VOUT.n9 0.0431667
R28 VOUT.n279 VOUT.n10 0.0431667
R29 VOUT.n281 VOUT.n279 0.0411667
R30 VOUT VOUT.n281 0.0292333
R31 VOUT.n281 VOUT.n280 2.0917
R32 VOUT.n280 VOUT.t132 0.298579
R33 VOUT.n280 VOUT.t136 35.4764
R34 VOUT.n11 VOUT.n83 1.8005
R35 VOUT.n12 VOUT.n150 1.8005
R36 VOUT.n11 VOUT.n12 0.214769
R37 VOUT.n279 VOUT.n11 0.267511
R38 VOUT.n12 VOUT.n278 2.01477
R39 VOUT.n54 VOUT.n19 2.01477
R40 VOUT.n57 VOUT.n20 2.01477
R41 VOUT.n60 VOUT.n21 2.01477
R42 VOUT.n63 VOUT.n22 2.01477
R43 VOUT.n66 VOUT.n23 2.01477
R44 VOUT.n69 VOUT.n24 2.01477
R45 VOUT.n72 VOUT.n25 2.01477
R46 VOUT.n75 VOUT.n26 2.01477
R47 VOUT.n78 VOUT.n27 2.01477
R48 VOUT.n81 VOUT.n28 2.01477
R49 VOUT.n149 VOUT.n29 2.01477
R50 VOUT.n214 VOUT.n14 6.1745
R51 VOUT.n16 VOUT.n14 0.4001
R52 VOUT.n19 VOUT.n16 0.3461
R53 VOUT.n19 VOUT.n18 0.0545
R54 VOUT.n18 VOUT.n216 0.4001
R55 VOUT.n216 VOUT.n218 0.4001
R56 VOUT.n20 VOUT.n218 0.2993
R57 VOUT.n20 VOUT.n220 0.1013
R58 VOUT.n220 VOUT.n222 0.4001
R59 VOUT.n222 VOUT.n224 0.4001
R60 VOUT.n21 VOUT.n224 0.2525
R61 VOUT.n21 VOUT.n226 0.1481
R62 VOUT.n226 VOUT.n228 0.4001
R63 VOUT.n228 VOUT.n230 0.4001
R64 VOUT.n22 VOUT.n230 0.2057
R65 VOUT.n22 VOUT.n232 0.1949
R66 VOUT.n232 VOUT.n234 0.4001
R67 VOUT.n236 VOUT.n234 0.4001
R68 VOUT.n23 VOUT.n236 0.1589
R69 VOUT.n23 VOUT.n238 0.2417
R70 VOUT.n238 VOUT.n240 0.4001
R71 VOUT.n242 VOUT.n240 0.4001
R72 VOUT.n24 VOUT.n242 0.1121
R73 VOUT.n24 VOUT.n244 0.2885
R74 VOUT.n244 VOUT.n246 0.4001
R75 VOUT.n248 VOUT.n246 0.4001
R76 VOUT.n25 VOUT.n248 0.0653
R77 VOUT.n25 VOUT.n250 0.3353
R78 VOUT.n250 VOUT.n252 0.4001
R79 VOUT.n254 VOUT.n252 0.4001
R80 VOUT.n26 VOUT.n254 0.0185
R81 VOUT.n26 VOUT.n256 0.3821
R82 VOUT.n256 VOUT.n258 0.4001
R83 VOUT.n27 VOUT.n258 0.3713
R84 VOUT.n27 VOUT.n260 0.0293
R85 VOUT.n260 VOUT.n262 0.4001
R86 VOUT.n262 VOUT.n264 0.4001
R87 VOUT.n28 VOUT.n264 0.3245
R88 VOUT.n28 VOUT.n266 0.0761
R89 VOUT.n266 VOUT.n268 0.4001
R90 VOUT.n268 VOUT.n270 0.4001
R91 VOUT.n29 VOUT.n270 0.2777
R92 VOUT.n29 VOUT.n272 0.1229
R93 VOUT.n272 VOUT.n274 0.4001
R94 VOUT.n274 VOUT.n276 0.4001
R95 VOUT.n278 VOUT.n276 0.2309
R96 VOUT.n278 VOUT.n277 6.29495
R97 VOUT.n277 VOUT.t131 0.653833
R98 VOUT.n277 VOUT.t163 0.653833
R99 VOUT.n276 VOUT.n275 6.12575
R100 VOUT.n275 VOUT.t21 0.653833
R101 VOUT.n275 VOUT.t134 0.653833
R102 VOUT.n274 VOUT.n273 6.12575
R103 VOUT.n273 VOUT.t27 0.653833
R104 VOUT.n273 VOUT.t162 0.653833
R105 VOUT.n272 VOUT.n271 6.12575
R106 VOUT.n271 VOUT.t164 0.653833
R107 VOUT.n271 VOUT.t9 0.653833
R108 VOUT.n270 VOUT.n269 6.12575
R109 VOUT.n269 VOUT.t19 0.653833
R110 VOUT.n269 VOUT.t125 0.653833
R111 VOUT.n268 VOUT.n267 6.12575
R112 VOUT.n267 VOUT.t18 0.653833
R113 VOUT.n267 VOUT.t25 0.653833
R114 VOUT.n266 VOUT.n265 6.12575
R115 VOUT.n265 VOUT.t29 0.653833
R116 VOUT.n265 VOUT.t2 0.653833
R117 VOUT.n264 VOUT.n263 6.12575
R118 VOUT.n263 VOUT.t7 0.653833
R119 VOUT.n263 VOUT.t10 0.653833
R120 VOUT.n262 VOUT.n261 6.12575
R121 VOUT.n261 VOUT.t147 0.653833
R122 VOUT.n261 VOUT.t120 0.653833
R123 VOUT.n260 VOUT.n259 6.12575
R124 VOUT.n259 VOUT.t22 0.653833
R125 VOUT.n259 VOUT.t1 0.653833
R126 VOUT.n258 VOUT.n257 6.12575
R127 VOUT.n257 VOUT.t165 0.653833
R128 VOUT.n257 VOUT.t142 0.653833
R129 VOUT.n256 VOUT.n255 6.12575
R130 VOUT.n255 VOUT.t6 0.653833
R131 VOUT.n255 VOUT.t199 0.653833
R132 VOUT.n254 VOUT.n253 6.12575
R133 VOUT.n253 VOUT.t55 0.653833
R134 VOUT.n253 VOUT.t14 0.653833
R135 VOUT.n252 VOUT.n251 6.12575
R136 VOUT.n251 VOUT.t48 0.653833
R137 VOUT.n251 VOUT.t166 0.653833
R138 VOUT.n250 VOUT.n249 6.12575
R139 VOUT.n249 VOUT.t30 0.653833
R140 VOUT.n249 VOUT.t37 0.653833
R141 VOUT.n248 VOUT.n247 6.12575
R142 VOUT.n247 VOUT.t20 0.653833
R143 VOUT.n247 VOUT.t173 0.653833
R144 VOUT.n246 VOUT.n245 6.12575
R145 VOUT.n245 VOUT.t16 0.653833
R146 VOUT.n245 VOUT.t15 0.653833
R147 VOUT.n244 VOUT.n243 6.12575
R148 VOUT.n243 VOUT.t67 0.653833
R149 VOUT.n243 VOUT.t69 0.653833
R150 VOUT.n242 VOUT.n241 6.12575
R151 VOUT.n241 VOUT.t198 0.653833
R152 VOUT.n241 VOUT.t35 0.653833
R153 VOUT.n240 VOUT.n239 6.12575
R154 VOUT.n239 VOUT.t167 0.653833
R155 VOUT.n239 VOUT.t200 0.653833
R156 VOUT.n238 VOUT.n237 6.12575
R157 VOUT.n237 VOUT.t161 0.653833
R158 VOUT.n237 VOUT.t45 0.653833
R159 VOUT.n236 VOUT.n235 6.12575
R160 VOUT.n235 VOUT.t13 0.653833
R161 VOUT.n235 VOUT.t49 0.653833
R162 VOUT.n234 VOUT.n233 6.12575
R163 VOUT.n233 VOUT.t23 0.653833
R164 VOUT.n233 VOUT.t205 0.653833
R165 VOUT.n232 VOUT.n231 6.12575
R166 VOUT.n231 VOUT.t8 0.653833
R167 VOUT.n231 VOUT.t54 0.653833
R168 VOUT.n230 VOUT.n229 6.12575
R169 VOUT.n229 VOUT.t139 0.653833
R170 VOUT.n229 VOUT.t140 0.653833
R171 VOUT.n228 VOUT.n227 6.12575
R172 VOUT.n227 VOUT.t138 0.653833
R173 VOUT.n227 VOUT.t46 0.653833
R174 VOUT.n226 VOUT.n225 6.12575
R175 VOUT.n225 VOUT.t47 0.653833
R176 VOUT.n225 VOUT.t156 0.653833
R177 VOUT.n224 VOUT.n223 6.12575
R178 VOUT.n223 VOUT.t11 0.653833
R179 VOUT.n223 VOUT.t141 0.653833
R180 VOUT.n222 VOUT.n221 6.12575
R181 VOUT.n221 VOUT.t42 0.653833
R182 VOUT.n221 VOUT.t183 0.653833
R183 VOUT.n220 VOUT.n219 6.12575
R184 VOUT.n219 VOUT.t137 0.653833
R185 VOUT.n219 VOUT.t197 0.653833
R186 VOUT.n218 VOUT.n217 6.12575
R187 VOUT.n217 VOUT.t43 0.653833
R188 VOUT.n217 VOUT.t172 0.653833
R189 VOUT.n216 VOUT.n215 6.12575
R190 VOUT.n215 VOUT.t3 0.653833
R191 VOUT.n215 VOUT.t36 0.653833
R192 VOUT.n54 VOUT.n36 1.8005
R193 VOUT.n57 VOUT.n37 1.8005
R194 VOUT.n60 VOUT.n38 1.8005
R195 VOUT.n63 VOUT.n39 1.8005
R196 VOUT.n66 VOUT.n40 1.8005
R197 VOUT.n69 VOUT.n41 1.8005
R198 VOUT.n72 VOUT.n42 1.8005
R199 VOUT.n75 VOUT.n43 1.8005
R200 VOUT.n78 VOUT.n44 1.8005
R201 VOUT.n81 VOUT.n45 1.8005
R202 VOUT.n31 VOUT.n214 5.0603
R203 VOUT.n33 VOUT.n31 0.4001
R204 VOUT.n36 VOUT.n33 0.3461
R205 VOUT.n36 VOUT.n35 0.0545
R206 VOUT.n35 VOUT.n152 0.4001
R207 VOUT.n152 VOUT.n154 0.4001
R208 VOUT.n37 VOUT.n154 0.2993
R209 VOUT.n37 VOUT.n156 0.1013
R210 VOUT.n156 VOUT.n158 0.4001
R211 VOUT.n158 VOUT.n160 0.4001
R212 VOUT.n38 VOUT.n160 0.2525
R213 VOUT.n38 VOUT.n162 0.1481
R214 VOUT.n162 VOUT.n164 0.4001
R215 VOUT.n164 VOUT.n166 0.4001
R216 VOUT.n39 VOUT.n166 0.2057
R217 VOUT.n39 VOUT.n168 0.1949
R218 VOUT.n168 VOUT.n170 0.4001
R219 VOUT.n172 VOUT.n170 0.4001
R220 VOUT.n40 VOUT.n172 0.1589
R221 VOUT.n40 VOUT.n174 0.2417
R222 VOUT.n174 VOUT.n176 0.4001
R223 VOUT.n178 VOUT.n176 0.4001
R224 VOUT.n41 VOUT.n178 0.1121
R225 VOUT.n41 VOUT.n180 0.2885
R226 VOUT.n180 VOUT.n182 0.4001
R227 VOUT.n184 VOUT.n182 0.4001
R228 VOUT.n42 VOUT.n184 0.0653
R229 VOUT.n42 VOUT.n186 0.3353
R230 VOUT.n186 VOUT.n188 0.4001
R231 VOUT.n190 VOUT.n188 0.4001
R232 VOUT.n43 VOUT.n190 0.0185
R233 VOUT.n43 VOUT.n192 0.3821
R234 VOUT.n192 VOUT.n194 0.4001
R235 VOUT.n44 VOUT.n194 0.3713
R236 VOUT.n44 VOUT.n196 0.0293
R237 VOUT.n196 VOUT.n198 0.4001
R238 VOUT.n198 VOUT.n200 0.4001
R239 VOUT.n45 VOUT.n200 0.3245
R240 VOUT.n45 VOUT.n202 0.0761
R241 VOUT.n202 VOUT.n204 0.4001
R242 VOUT.n204 VOUT.n206 0.4001
R243 VOUT.n46 VOUT.n206 0.2777
R244 VOUT.n46 VOUT.n208 0.1229
R245 VOUT.n208 VOUT.n210 0.4001
R246 VOUT.n210 VOUT.n212 0.4001
R247 VOUT.n150 VOUT.n212 0.2309
R248 VOUT.n150 VOUT.n213 6.29495
R249 VOUT.n213 VOUT.t24 0.653833
R250 VOUT.n213 VOUT.t17 0.653833
R251 VOUT.n212 VOUT.n211 6.12575
R252 VOUT.n211 VOUT.t4 0.653833
R253 VOUT.n211 VOUT.t28 0.653833
R254 VOUT.n210 VOUT.n209 6.12575
R255 VOUT.n209 VOUT.t0 0.653833
R256 VOUT.n209 VOUT.t56 0.653833
R257 VOUT.n208 VOUT.n207 6.12575
R258 VOUT.n207 VOUT.t44 0.653833
R259 VOUT.n207 VOUT.t130 0.653833
R260 VOUT.n206 VOUT.n205 6.12575
R261 VOUT.n205 VOUT.t26 0.653833
R262 VOUT.n205 VOUT.t57 0.653833
R263 VOUT.n204 VOUT.n203 6.12575
R264 VOUT.n203 VOUT.t179 0.653833
R265 VOUT.n203 VOUT.t5 0.653833
R266 VOUT.n202 VOUT.n201 6.12575
R267 VOUT.n201 VOUT.t181 0.653833
R268 VOUT.n201 VOUT.t180 0.653833
R269 VOUT.n200 VOUT.n199 6.12575
R270 VOUT.n199 VOUT.t157 0.653833
R271 VOUT.n199 VOUT.t182 0.653833
R272 VOUT.n198 VOUT.n197 6.12575
R273 VOUT.n197 VOUT.t159 0.653833
R274 VOUT.n197 VOUT.t158 0.653833
R275 VOUT.n196 VOUT.n195 6.12575
R276 VOUT.n195 VOUT.t148 0.653833
R277 VOUT.n195 VOUT.t160 0.653833
R278 VOUT.n194 VOUT.n193 6.12575
R279 VOUT.n193 VOUT.t150 0.653833
R280 VOUT.n193 VOUT.t149 0.653833
R281 VOUT.n192 VOUT.n191 6.12575
R282 VOUT.n191 VOUT.t126 0.653833
R283 VOUT.n191 VOUT.t151 0.653833
R284 VOUT.n190 VOUT.n189 6.12575
R285 VOUT.n189 VOUT.t128 0.653833
R286 VOUT.n189 VOUT.t127 0.653833
R287 VOUT.n188 VOUT.n187 6.12575
R288 VOUT.n187 VOUT.t210 0.653833
R289 VOUT.n187 VOUT.t129 0.653833
R290 VOUT.n186 VOUT.n185 6.12575
R291 VOUT.n185 VOUT.t212 0.653833
R292 VOUT.n185 VOUT.t211 0.653833
R293 VOUT.n184 VOUT.n183 6.12575
R294 VOUT.n183 VOUT.t31 0.653833
R295 VOUT.n183 VOUT.t213 0.653833
R296 VOUT.n182 VOUT.n181 6.12575
R297 VOUT.n181 VOUT.t33 0.653833
R298 VOUT.n181 VOUT.t32 0.653833
R299 VOUT.n180 VOUT.n179 6.12575
R300 VOUT.n179 VOUT.t152 0.653833
R301 VOUT.n179 VOUT.t34 0.653833
R302 VOUT.n178 VOUT.n177 6.12575
R303 VOUT.n177 VOUT.t154 0.653833
R304 VOUT.n177 VOUT.t153 0.653833
R305 VOUT.n176 VOUT.n175 6.12575
R306 VOUT.n175 VOUT.t184 0.653833
R307 VOUT.n175 VOUT.t155 0.653833
R308 VOUT.n174 VOUT.n173 6.12575
R309 VOUT.n173 VOUT.t186 0.653833
R310 VOUT.n173 VOUT.t185 0.653833
R311 VOUT.n172 VOUT.n171 6.12575
R312 VOUT.n171 VOUT.t188 0.653833
R313 VOUT.n171 VOUT.t187 0.653833
R314 VOUT.n170 VOUT.n169 6.12575
R315 VOUT.n169 VOUT.t190 0.653833
R316 VOUT.n169 VOUT.t189 0.653833
R317 VOUT.n168 VOUT.n167 6.12575
R318 VOUT.n167 VOUT.t206 0.653833
R319 VOUT.n167 VOUT.t191 0.653833
R320 VOUT.n166 VOUT.n165 6.12575
R321 VOUT.n165 VOUT.t208 0.653833
R322 VOUT.n165 VOUT.t207 0.653833
R323 VOUT.n164 VOUT.n163 6.12575
R324 VOUT.n163 VOUT.t192 0.653833
R325 VOUT.n163 VOUT.t209 0.653833
R326 VOUT.n162 VOUT.n161 6.12575
R327 VOUT.n161 VOUT.t194 0.653833
R328 VOUT.n161 VOUT.t193 0.653833
R329 VOUT.n160 VOUT.n159 6.12575
R330 VOUT.n159 VOUT.t143 0.653833
R331 VOUT.n159 VOUT.t195 0.653833
R332 VOUT.n158 VOUT.n157 6.12575
R333 VOUT.n157 VOUT.t145 0.653833
R334 VOUT.n157 VOUT.t144 0.653833
R335 VOUT.n156 VOUT.n155 6.12575
R336 VOUT.n155 VOUT.t50 0.653833
R337 VOUT.n155 VOUT.t146 0.653833
R338 VOUT.n154 VOUT.n153 6.12575
R339 VOUT.n153 VOUT.t52 0.653833
R340 VOUT.n153 VOUT.t51 0.653833
R341 VOUT.n152 VOUT.n151 6.12575
R342 VOUT.n151 VOUT.t38 0.653833
R343 VOUT.n151 VOUT.t53 0.653833
R344 VOUT.n149 VOUT.n46 1.8005
R345 VOUT.n148 VOUT.n149 0.214769
R346 VOUT.n10 VOUT.n148 0.267511
R347 VOUT.n148 VOUT.n147 1.8005
R348 VOUT.n214 VOUT.n48 6.1745
R349 VOUT.n50 VOUT.n48 0.4001
R350 VOUT.n53 VOUT.n50 0.3461
R351 VOUT.n53 VOUT.n52 0.0545
R352 VOUT.n52 VOUT.n85 0.4001
R353 VOUT.n85 VOUT.n87 0.4001
R354 VOUT.n56 VOUT.n87 0.2993
R355 VOUT.n56 VOUT.n89 0.1013
R356 VOUT.n89 VOUT.n91 0.4001
R357 VOUT.n91 VOUT.n93 0.4001
R358 VOUT.n59 VOUT.n93 0.2525
R359 VOUT.n59 VOUT.n95 0.1481
R360 VOUT.n95 VOUT.n97 0.4001
R361 VOUT.n97 VOUT.n99 0.4001
R362 VOUT.n62 VOUT.n99 0.2057
R363 VOUT.n62 VOUT.n101 0.1949
R364 VOUT.n101 VOUT.n103 0.4001
R365 VOUT.n105 VOUT.n103 0.4001
R366 VOUT.n65 VOUT.n105 0.1589
R367 VOUT.n65 VOUT.n107 0.2417
R368 VOUT.n107 VOUT.n109 0.4001
R369 VOUT.n111 VOUT.n109 0.4001
R370 VOUT.n68 VOUT.n111 0.1121
R371 VOUT.n68 VOUT.n113 0.2885
R372 VOUT.n113 VOUT.n115 0.4001
R373 VOUT.n117 VOUT.n115 0.4001
R374 VOUT.n71 VOUT.n117 0.0653
R375 VOUT.n71 VOUT.n119 0.3353
R376 VOUT.n119 VOUT.n121 0.4001
R377 VOUT.n123 VOUT.n121 0.4001
R378 VOUT.n74 VOUT.n123 0.0185
R379 VOUT.n74 VOUT.n125 0.3821
R380 VOUT.n125 VOUT.n127 0.4001
R381 VOUT.n77 VOUT.n127 0.3713
R382 VOUT.n77 VOUT.n129 0.0293
R383 VOUT.n129 VOUT.n131 0.4001
R384 VOUT.n131 VOUT.n133 0.4001
R385 VOUT.n80 VOUT.n133 0.3245
R386 VOUT.n80 VOUT.n135 0.0761
R387 VOUT.n135 VOUT.n137 0.4001
R388 VOUT.n137 VOUT.n139 0.4001
R389 VOUT.n147 VOUT.n139 0.2777
R390 VOUT.n147 VOUT.n141 0.1229
R391 VOUT.n141 VOUT.n143 0.4001
R392 VOUT.n143 VOUT.n145 0.4001
R393 VOUT.n83 VOUT.n145 0.2309
R394 VOUT.n83 VOUT.n146 6.29495
R395 VOUT.n146 VOUT.t175 0.653833
R396 VOUT.n146 VOUT.t61 0.653833
R397 VOUT.n145 VOUT.n144 6.12575
R398 VOUT.n144 VOUT.t177 0.653833
R399 VOUT.n144 VOUT.t176 0.653833
R400 VOUT.n143 VOUT.n142 6.12575
R401 VOUT.n142 VOUT.t168 0.653833
R402 VOUT.n142 VOUT.t178 0.653833
R403 VOUT.n141 VOUT.n140 6.12575
R404 VOUT.n140 VOUT.t170 0.653833
R405 VOUT.n140 VOUT.t169 0.653833
R406 VOUT.n139 VOUT.n138 6.12575
R407 VOUT.n138 VOUT.t116 0.653833
R408 VOUT.n138 VOUT.t171 0.653833
R409 VOUT.n137 VOUT.n136 6.12575
R410 VOUT.n136 VOUT.t118 0.653833
R411 VOUT.n136 VOUT.t117 0.653833
R412 VOUT.n135 VOUT.n134 6.12575
R413 VOUT.n134 VOUT.t112 0.653833
R414 VOUT.n134 VOUT.t119 0.653833
R415 VOUT.n133 VOUT.n132 6.12575
R416 VOUT.n132 VOUT.t114 0.653833
R417 VOUT.n132 VOUT.t113 0.653833
R418 VOUT.n131 VOUT.n130 6.12575
R419 VOUT.n130 VOUT.t108 0.653833
R420 VOUT.n130 VOUT.t115 0.653833
R421 VOUT.n129 VOUT.n128 6.12575
R422 VOUT.n128 VOUT.t110 0.653833
R423 VOUT.n128 VOUT.t109 0.653833
R424 VOUT.n127 VOUT.n126 6.12575
R425 VOUT.n126 VOUT.t104 0.653833
R426 VOUT.n126 VOUT.t111 0.653833
R427 VOUT.n125 VOUT.n124 6.12575
R428 VOUT.n124 VOUT.t106 0.653833
R429 VOUT.n124 VOUT.t105 0.653833
R430 VOUT.n123 VOUT.n122 6.12575
R431 VOUT.n122 VOUT.t62 0.653833
R432 VOUT.n122 VOUT.t107 0.653833
R433 VOUT.n121 VOUT.n120 6.12575
R434 VOUT.n120 VOUT.t64 0.653833
R435 VOUT.n120 VOUT.t63 0.653833
R436 VOUT.n119 VOUT.n118 6.12575
R437 VOUT.n118 VOUT.t100 0.653833
R438 VOUT.n118 VOUT.t65 0.653833
R439 VOUT.n117 VOUT.n116 6.12575
R440 VOUT.n116 VOUT.t102 0.653833
R441 VOUT.n116 VOUT.t101 0.653833
R442 VOUT.n115 VOUT.n114 6.12575
R443 VOUT.n114 VOUT.t96 0.653833
R444 VOUT.n114 VOUT.t103 0.653833
R445 VOUT.n113 VOUT.n112 6.12575
R446 VOUT.n112 VOUT.t98 0.653833
R447 VOUT.n112 VOUT.t97 0.653833
R448 VOUT.n111 VOUT.n110 6.12575
R449 VOUT.n110 VOUT.t92 0.653833
R450 VOUT.n110 VOUT.t99 0.653833
R451 VOUT.n109 VOUT.n108 6.12575
R452 VOUT.n108 VOUT.t94 0.653833
R453 VOUT.n108 VOUT.t93 0.653833
R454 VOUT.n107 VOUT.n106 6.12575
R455 VOUT.n106 VOUT.t201 0.653833
R456 VOUT.n106 VOUT.t95 0.653833
R457 VOUT.n105 VOUT.n104 6.12575
R458 VOUT.n104 VOUT.t203 0.653833
R459 VOUT.n104 VOUT.t202 0.653833
R460 VOUT.n103 VOUT.n102 6.12575
R461 VOUT.n102 VOUT.t88 0.653833
R462 VOUT.n102 VOUT.t204 0.653833
R463 VOUT.n101 VOUT.n100 6.12575
R464 VOUT.n100 VOUT.t90 0.653833
R465 VOUT.n100 VOUT.t89 0.653833
R466 VOUT.n99 VOUT.n98 6.12575
R467 VOUT.n98 VOUT.t84 0.653833
R468 VOUT.n98 VOUT.t91 0.653833
R469 VOUT.n97 VOUT.n96 6.12575
R470 VOUT.n96 VOUT.t86 0.653833
R471 VOUT.n96 VOUT.t85 0.653833
R472 VOUT.n95 VOUT.n94 6.12575
R473 VOUT.n94 VOUT.t80 0.653833
R474 VOUT.n94 VOUT.t87 0.653833
R475 VOUT.n93 VOUT.n92 6.12575
R476 VOUT.n92 VOUT.t82 0.653833
R477 VOUT.n92 VOUT.t81 0.653833
R478 VOUT.n91 VOUT.n90 6.12575
R479 VOUT.n90 VOUT.t76 0.653833
R480 VOUT.n90 VOUT.t83 0.653833
R481 VOUT.n89 VOUT.n88 6.12575
R482 VOUT.n88 VOUT.t78 0.653833
R483 VOUT.n88 VOUT.t77 0.653833
R484 VOUT.n87 VOUT.n86 6.12575
R485 VOUT.n86 VOUT.t121 0.653833
R486 VOUT.n86 VOUT.t79 0.653833
R487 VOUT.n85 VOUT.n84 6.12575
R488 VOUT.n84 VOUT.t123 0.653833
R489 VOUT.n84 VOUT.t122 0.653833
R490 VOUT.n82 VOUT.n80 1.8005
R491 VOUT.n82 VOUT.n81 0.214769
R492 VOUT.n9 VOUT.n82 0.267511
R493 VOUT.n79 VOUT.n77 1.8005
R494 VOUT.n79 VOUT.n78 0.214769
R495 VOUT.n8 VOUT.n79 0.267511
R496 VOUT.n76 VOUT.n74 1.8005
R497 VOUT.n76 VOUT.n75 0.214769
R498 VOUT.n7 VOUT.n76 0.267511
R499 VOUT.n73 VOUT.n71 1.8005
R500 VOUT.n73 VOUT.n72 0.214769
R501 VOUT.n6 VOUT.n73 0.267511
R502 VOUT.n70 VOUT.n68 1.8005
R503 VOUT.n70 VOUT.n69 0.214769
R504 VOUT.n5 VOUT.n70 0.267511
R505 VOUT.n67 VOUT.n65 1.8005
R506 VOUT.n67 VOUT.n66 0.214769
R507 VOUT.n4 VOUT.n67 0.267511
R508 VOUT.n64 VOUT.n62 1.8005
R509 VOUT.n64 VOUT.n63 0.214769
R510 VOUT.n3 VOUT.n64 0.267511
R511 VOUT.n61 VOUT.n59 1.8005
R512 VOUT.n61 VOUT.n60 0.214769
R513 VOUT.n2 VOUT.n61 0.267511
R514 VOUT.n58 VOUT.n56 1.8005
R515 VOUT.n58 VOUT.n57 0.214769
R516 VOUT.n1 VOUT.n58 0.267511
R517 VOUT.n55 VOUT.n53 1.8005
R518 VOUT.n55 VOUT.n54 0.214769
R519 VOUT.n1 VOUT.n55 0.310177
R520 VOUT.n52 VOUT.n51 6.12575
R521 VOUT.n51 VOUT.t72 0.653833
R522 VOUT.n51 VOUT.t124 0.653833
R523 VOUT.n50 VOUT.n49 6.12575
R524 VOUT.n49 VOUT.t74 0.653833
R525 VOUT.n49 VOUT.t73 0.653833
R526 VOUT.n48 VOUT.n47 6.12575
R527 VOUT.n47 VOUT.t71 0.653833
R528 VOUT.n47 VOUT.t75 0.653833
R529 VOUT.n35 VOUT.n34 6.12575
R530 VOUT.n34 VOUT.t40 0.653833
R531 VOUT.n34 VOUT.t39 0.653833
R532 VOUT.n33 VOUT.n32 6.12575
R533 VOUT.n32 VOUT.t58 0.653833
R534 VOUT.n32 VOUT.t41 0.653833
R535 VOUT.n31 VOUT.n30 6.12575
R536 VOUT.n30 VOUT.t60 0.653833
R537 VOUT.n30 VOUT.t59 0.653833
R538 VOUT.n18 VOUT.n17 6.12575
R539 VOUT.n17 VOUT.t196 0.653833
R540 VOUT.n17 VOUT.t70 0.653833
R541 VOUT.n16 VOUT.n15 6.12575
R542 VOUT.n15 VOUT.t68 0.653833
R543 VOUT.n15 VOUT.t174 0.653833
R544 VOUT.n14 VOUT.n13 6.12575
R545 VOUT.n13 VOUT.t66 0.653833
R546 VOUT.n13 VOUT.t135 0.653833
R547 VOUT.n0 VOUT.t12 56.1999
R548 VIN VIN.n1 0.3341
R549 VIN.n1 VIN.n2 0.319433
R550 VIN.n2 VIN.n3 0.0431667
R551 VIN.n3 VIN.n4 0.0431667
R552 VIN.n4 VIN.n5 0.0431667
R553 VIN.n5 VIN.n6 0.0431667
R554 VIN.n6 VIN.n7 0.0431667
R555 VIN.n7 VIN.n8 0.0431667
R556 VIN.n8 VIN.n9 0.0431667
R557 VIN.n9 VIN.n10 0.0431667
R558 VIN.n10 VIN.n11 0.0431667
R559 VIN.n11 VIN.n12 0.0431667
R560 VIN.n13 VIN.n1299 1.8005
R561 VIN.n14 VIN.n1370 1.8005
R562 VIN.n1505 VIN.n598 1.99019
R563 VIN.n14 VIN.n1505 0.214769
R564 VIN.n13 VIN.n14 0.214769
R565 VIN.n12 VIN.n13 0.580177
R566 VIN.n1505 VIN.n1504 1.8005
R567 VIN.n70 VIN.n18 1.8005
R568 VIN.n296 VIN.n19 1.8005
R569 VIN.n76 VIN.n20 1.8005
R570 VIN.n330 VIN.n21 1.8005
R571 VIN.n82 VIN.n22 1.8005
R572 VIN.n87 VIN.n23 1.8005
R573 VIN.n592 VIN.n24 1.8005
R574 VIN.n54 VIN.n25 2.01477
R575 VIN.n596 VIN.n26 1.8005
R576 VIN.n1297 VIN.n27 1.8005
R577 VIN.n1368 VIN.n28 1.8005
R578 VIN.n1437 VIN.n15 5.8127
R579 VIN.n18 VIN.n15 0.3695
R580 VIN.n18 VIN.n17 0.0311
R581 VIN.n17 VIN.n1439 0.4001
R582 VIN.n1439 VIN.n1441 0.4001
R583 VIN.n19 VIN.n1441 0.3227
R584 VIN.n19 VIN.n1443 0.0779
R585 VIN.n1443 VIN.n1445 0.4001
R586 VIN.n1445 VIN.n1447 0.4001
R587 VIN.n20 VIN.n1447 0.2759
R588 VIN.n20 VIN.n1449 0.1247
R589 VIN.n1449 VIN.n1451 0.4001
R590 VIN.n1451 VIN.n1453 0.4001
R591 VIN.n21 VIN.n1453 0.2291
R592 VIN.n21 VIN.n1455 0.1715
R593 VIN.n1455 VIN.n1457 0.4001
R594 VIN.n1457 VIN.n1459 0.4001
R595 VIN.n22 VIN.n1459 0.1823
R596 VIN.n22 VIN.n1461 0.2183
R597 VIN.n1461 VIN.n1463 0.4001
R598 VIN.n1465 VIN.n1463 0.4001
R599 VIN.n23 VIN.n1465 0.1355
R600 VIN.n23 VIN.n1467 0.2651
R601 VIN.n1467 VIN.n1469 0.4001
R602 VIN.n1471 VIN.n1469 0.4001
R603 VIN.n24 VIN.n1471 0.0887
R604 VIN.n24 VIN.n1473 0.3119
R605 VIN.n1473 VIN.n1475 0.4001
R606 VIN.n1477 VIN.n1475 0.4001
R607 VIN.n25 VIN.n1477 0.0419
R608 VIN.n25 VIN.n1479 0.3587
R609 VIN.n1479 VIN.n1481 0.4001
R610 VIN.n26 VIN.n1481 0.3947
R611 VIN.n26 VIN.n1483 0.0059
R612 VIN.n1483 VIN.n1485 0.4001
R613 VIN.n1485 VIN.n1487 0.4001
R614 VIN.n27 VIN.n1487 0.3479
R615 VIN.n27 VIN.n1489 0.0527
R616 VIN.n1489 VIN.n1491 0.4001
R617 VIN.n1491 VIN.n1493 0.4001
R618 VIN.n28 VIN.n1493 0.3011
R619 VIN.n28 VIN.n1495 0.0995
R620 VIN.n1495 VIN.n1497 0.4001
R621 VIN.n1497 VIN.n1499 0.4001
R622 VIN.n1504 VIN.n1499 0.2543
R623 VIN.n1504 VIN.n1501 0.1463
R624 VIN.n1501 VIN.n1503 0.4001
R625 VIN.n1503 VIN.t293 7.02216
R626 VIN.n1503 VIN.n1502 5.96923
R627 VIN.n1502 VIN.t257 0.653833
R628 VIN.n1502 VIN.t255 0.653833
R629 VIN.n1501 VIN.n1500 5.96923
R630 VIN.n1500 VIN.t292 0.653833
R631 VIN.n1500 VIN.t47 0.653833
R632 VIN.n1499 VIN.n1498 5.96923
R633 VIN.n1498 VIN.t21 0.653833
R634 VIN.n1498 VIN.t57 0.653833
R635 VIN.n1497 VIN.n1496 5.96923
R636 VIN.n1496 VIN.t213 0.653833
R637 VIN.n1496 VIN.t294 0.653833
R638 VIN.n1495 VIN.n1494 5.96923
R639 VIN.n1494 VIN.t55 0.653833
R640 VIN.n1494 VIN.t44 0.653833
R641 VIN.n1493 VIN.n1492 5.96923
R642 VIN.n1492 VIN.t5 0.653833
R643 VIN.n1492 VIN.t42 0.653833
R644 VIN.n1491 VIN.n1490 5.96923
R645 VIN.n1490 VIN.t25 0.653833
R646 VIN.n1490 VIN.t62 0.653833
R647 VIN.n1489 VIN.n1488 5.96923
R648 VIN.n1488 VIN.t208 0.653833
R649 VIN.n1488 VIN.t16 0.653833
R650 VIN.n1487 VIN.n1486 5.96923
R651 VIN.n1486 VIN.t3 0.653833
R652 VIN.n1486 VIN.t276 0.653833
R653 VIN.n1485 VIN.n1484 5.96923
R654 VIN.n1484 VIN.t271 0.653833
R655 VIN.n1484 VIN.t49 0.653833
R656 VIN.n1483 VIN.n1482 5.96923
R657 VIN.n1482 VIN.t332 0.653833
R658 VIN.n1482 VIN.t295 0.653833
R659 VIN.n1481 VIN.n1480 5.96923
R660 VIN.n1480 VIN.t31 0.653833
R661 VIN.n1480 VIN.t13 0.653833
R662 VIN.n1479 VIN.n1478 5.96923
R663 VIN.n1478 VIN.t296 0.653833
R664 VIN.n1478 VIN.t119 0.653833
R665 VIN.n1477 VIN.n1476 5.96923
R666 VIN.n1476 VIN.t78 0.653833
R667 VIN.n1476 VIN.t103 0.653833
R668 VIN.n1475 VIN.n1474 5.96923
R669 VIN.n1474 VIN.t303 0.653833
R670 VIN.n1474 VIN.t64 0.653833
R671 VIN.n1473 VIN.n1472 5.96923
R672 VIN.n1472 VIN.t33 0.653833
R673 VIN.n1472 VIN.t46 0.653833
R674 VIN.n1471 VIN.n1470 5.96923
R675 VIN.n1470 VIN.t141 0.653833
R676 VIN.n1470 VIN.t37 0.653833
R677 VIN.n1469 VIN.n1468 5.96923
R678 VIN.n1468 VIN.t74 0.653833
R679 VIN.n1468 VIN.t139 0.653833
R680 VIN.n1467 VIN.n1466 5.96923
R681 VIN.n1466 VIN.t334 0.653833
R682 VIN.n1466 VIN.t331 0.653833
R683 VIN.n1465 VIN.n1464 5.96923
R684 VIN.n1464 VIN.t96 0.653833
R685 VIN.n1464 VIN.t297 0.653833
R686 VIN.n1463 VIN.n1462 5.96923
R687 VIN.n1462 VIN.t106 0.653833
R688 VIN.n1462 VIN.t291 0.653833
R689 VIN.n1461 VIN.n1460 5.96923
R690 VIN.n1460 VIN.t339 0.653833
R691 VIN.n1460 VIN.t29 0.653833
R692 VIN.n1459 VIN.n1458 5.96923
R693 VIN.n1458 VIN.t115 0.653833
R694 VIN.n1458 VIN.t52 0.653833
R695 VIN.n1457 VIN.n1456 5.96923
R696 VIN.n1456 VIN.t269 0.653833
R697 VIN.n1456 VIN.t18 0.653833
R698 VIN.n1455 VIN.n1454 5.96923
R699 VIN.n1454 VIN.t99 0.653833
R700 VIN.n1454 VIN.t268 0.653833
R701 VIN.n1453 VIN.n1452 5.96923
R702 VIN.n1452 VIN.t285 0.653833
R703 VIN.n1452 VIN.t267 0.653833
R704 VIN.n1451 VIN.n1450 5.96923
R705 VIN.n1450 VIN.t270 0.653833
R706 VIN.n1450 VIN.t101 0.653833
R707 VIN.n1449 VIN.n1448 5.96923
R708 VIN.n1448 VIN.t313 0.653833
R709 VIN.n1448 VIN.t27 0.653833
R710 VIN.n1447 VIN.n1446 5.96923
R711 VIN.n1446 VIN.t330 0.653833
R712 VIN.n1446 VIN.t90 0.653833
R713 VIN.n1445 VIN.n1444 5.96923
R714 VIN.n1444 VIN.t302 0.653833
R715 VIN.n1444 VIN.t266 0.653833
R716 VIN.n1443 VIN.n1442 5.96923
R717 VIN.n1442 VIN.t76 0.653833
R718 VIN.n1442 VIN.t92 0.653833
R719 VIN.n1441 VIN.n1440 5.96923
R720 VIN.n1440 VIN.t142 0.653833
R721 VIN.n1440 VIN.t7 0.653833
R722 VIN.n1439 VIN.n1438 5.96923
R723 VIN.n1438 VIN.t304 0.653833
R724 VIN.n1438 VIN.t327 0.653833
R725 VIN.n69 VIN.n32 1.8005
R726 VIN.n295 VIN.n33 1.8005
R727 VIN.n75 VIN.n34 1.8005
R728 VIN.n329 VIN.n35 1.8005
R729 VIN.n81 VIN.n36 1.8005
R730 VIN.n86 VIN.n37 1.8005
R731 VIN.n591 VIN.n38 1.8005
R732 VIN.n54 VIN.n39 1.8005
R733 VIN.n595 VIN.n40 1.8005
R734 VIN.n1296 VIN.n41 1.8005
R735 VIN.n29 VIN.n1437 4.6985
R736 VIN.n32 VIN.n29 0.3695
R737 VIN.n32 VIN.n31 0.0311
R738 VIN.n31 VIN.n1372 0.4001
R739 VIN.n1372 VIN.n1374 0.4001
R740 VIN.n33 VIN.n1374 0.3227
R741 VIN.n33 VIN.n1376 0.0779
R742 VIN.n1376 VIN.n1378 0.4001
R743 VIN.n1378 VIN.n1380 0.4001
R744 VIN.n34 VIN.n1380 0.2759
R745 VIN.n34 VIN.n1382 0.1247
R746 VIN.n1382 VIN.n1384 0.4001
R747 VIN.n1384 VIN.n1386 0.4001
R748 VIN.n35 VIN.n1386 0.2291
R749 VIN.n35 VIN.n1388 0.1715
R750 VIN.n1388 VIN.n1390 0.4001
R751 VIN.n1390 VIN.n1392 0.4001
R752 VIN.n36 VIN.n1392 0.1823
R753 VIN.n36 VIN.n1394 0.2183
R754 VIN.n1394 VIN.n1396 0.4001
R755 VIN.n1398 VIN.n1396 0.4001
R756 VIN.n37 VIN.n1398 0.1355
R757 VIN.n37 VIN.n1400 0.2651
R758 VIN.n1400 VIN.n1402 0.4001
R759 VIN.n1404 VIN.n1402 0.4001
R760 VIN.n38 VIN.n1404 0.0887
R761 VIN.n38 VIN.n1406 0.3119
R762 VIN.n1406 VIN.n1408 0.4001
R763 VIN.n1410 VIN.n1408 0.4001
R764 VIN.n39 VIN.n1410 0.0419
R765 VIN.n39 VIN.n1412 0.3587
R766 VIN.n1412 VIN.n1414 0.4001
R767 VIN.n40 VIN.n1414 0.3947
R768 VIN.n40 VIN.n1416 0.0059
R769 VIN.n1416 VIN.n1418 0.4001
R770 VIN.n1418 VIN.n1420 0.4001
R771 VIN.n41 VIN.n1420 0.3479
R772 VIN.n41 VIN.n1422 0.0527
R773 VIN.n1422 VIN.n1424 0.4001
R774 VIN.n1424 VIN.n1426 0.4001
R775 VIN.n42 VIN.n1426 0.3011
R776 VIN.n42 VIN.n1428 0.0995
R777 VIN.n1428 VIN.n1430 0.4001
R778 VIN.n1430 VIN.n1432 0.4001
R779 VIN.n1370 VIN.n1432 0.2543
R780 VIN.n1370 VIN.n1434 0.1463
R781 VIN.n1434 VIN.n1436 0.4001
R782 VIN.n1436 VIN.t40 7.02216
R783 VIN.n1436 VIN.n1435 5.96923
R784 VIN.n1435 VIN.t59 0.653833
R785 VIN.n1435 VIN.t54 0.653833
R786 VIN.n1434 VIN.n1433 5.96923
R787 VIN.n1433 VIN.t121 0.653833
R788 VIN.n1433 VIN.t9 0.653833
R789 VIN.n1432 VIN.n1431 5.96923
R790 VIN.n1431 VIN.t218 0.653833
R791 VIN.n1431 VIN.t1 0.653833
R792 VIN.n1430 VIN.n1429 5.96923
R793 VIN.n1429 VIN.t123 0.653833
R794 VIN.n1429 VIN.t94 0.653833
R795 VIN.n1428 VIN.n1427 5.96923
R796 VIN.n1427 VIN.t11 0.653833
R797 VIN.n1427 VIN.t56 0.653833
R798 VIN.n1426 VIN.n1425 5.96923
R799 VIN.n1425 VIN.t310 0.653833
R800 VIN.n1425 VIN.t309 0.653833
R801 VIN.n1424 VIN.n1423 5.96923
R802 VIN.n1423 VIN.t312 0.653833
R803 VIN.n1423 VIN.t311 0.653833
R804 VIN.n1422 VIN.n1421 5.96923
R805 VIN.n1421 VIN.t287 0.653833
R806 VIN.n1421 VIN.t286 0.653833
R807 VIN.n1420 VIN.n1419 5.96923
R808 VIN.n1419 VIN.t289 0.653833
R809 VIN.n1419 VIN.t288 0.653833
R810 VIN.n1418 VIN.n1417 5.96923
R811 VIN.n1417 VIN.t278 0.653833
R812 VIN.n1417 VIN.t277 0.653833
R813 VIN.n1416 VIN.n1415 5.96923
R814 VIN.n1415 VIN.t280 0.653833
R815 VIN.n1415 VIN.t279 0.653833
R816 VIN.n1414 VIN.n1413 5.96923
R817 VIN.n1413 VIN.t215 0.653833
R818 VIN.n1413 VIN.t214 0.653833
R819 VIN.n1412 VIN.n1411 5.96923
R820 VIN.n1411 VIN.t217 0.653833
R821 VIN.n1411 VIN.t216 0.653833
R822 VIN.n1410 VIN.n1409 5.96923
R823 VIN.n1409 VIN.t345 0.653833
R824 VIN.n1409 VIN.t344 0.653833
R825 VIN.n1408 VIN.n1407 5.96923
R826 VIN.n1407 VIN.t347 0.653833
R827 VIN.n1407 VIN.t346 0.653833
R828 VIN.n1406 VIN.n1405 5.96923
R829 VIN.n1405 VIN.t69 0.653833
R830 VIN.n1405 VIN.t68 0.653833
R831 VIN.n1404 VIN.n1403 5.96923
R832 VIN.n1403 VIN.t72 0.653833
R833 VIN.n1403 VIN.t70 0.653833
R834 VIN.n1402 VIN.n1401 5.96923
R835 VIN.n1401 VIN.t282 0.653833
R836 VIN.n1401 VIN.t281 0.653833
R837 VIN.n1400 VIN.n1399 5.96923
R838 VIN.n1399 VIN.t284 0.653833
R839 VIN.n1399 VIN.t283 0.653833
R840 VIN.n1398 VIN.n1397 5.96923
R841 VIN.n1397 VIN.t315 0.653833
R842 VIN.n1397 VIN.t314 0.653833
R843 VIN.n1396 VIN.n1395 5.96923
R844 VIN.n1395 VIN.t317 0.653833
R845 VIN.n1395 VIN.t316 0.653833
R846 VIN.n1394 VIN.n1393 5.96923
R847 VIN.n1393 VIN.t320 0.653833
R848 VIN.n1393 VIN.t318 0.653833
R849 VIN.n1392 VIN.n1391 5.96923
R850 VIN.n1391 VIN.t322 0.653833
R851 VIN.n1391 VIN.t321 0.653833
R852 VIN.n1390 VIN.n1389 5.96923
R853 VIN.n1389 VIN.t341 0.653833
R854 VIN.n1389 VIN.t340 0.653833
R855 VIN.n1388 VIN.n1387 5.96923
R856 VIN.n1387 VIN.t343 0.653833
R857 VIN.n1387 VIN.t342 0.653833
R858 VIN.n1386 VIN.n1385 5.96923
R859 VIN.n1385 VIN.t324 0.653833
R860 VIN.n1385 VIN.t323 0.653833
R861 VIN.n1384 VIN.n1383 5.96923
R862 VIN.n1383 VIN.t326 0.653833
R863 VIN.n1383 VIN.t325 0.653833
R864 VIN.n1382 VIN.n1381 5.96923
R865 VIN.n1381 VIN.t273 0.653833
R866 VIN.n1381 VIN.t272 0.653833
R867 VIN.n1380 VIN.n1379 5.96923
R868 VIN.n1379 VIN.t275 0.653833
R869 VIN.n1379 VIN.t274 0.653833
R870 VIN.n1378 VIN.n1377 5.96923
R871 VIN.n1377 VIN.t110 0.653833
R872 VIN.n1377 VIN.t108 0.653833
R873 VIN.n1376 VIN.n1375 5.96923
R874 VIN.n1375 VIN.t112 0.653833
R875 VIN.n1375 VIN.t111 0.653833
R876 VIN.n1374 VIN.n1373 5.96923
R877 VIN.n1373 VIN.t84 0.653833
R878 VIN.n1373 VIN.t82 0.653833
R879 VIN.n1372 VIN.n1371 5.96923
R880 VIN.n1371 VIN.t88 0.653833
R881 VIN.n1371 VIN.t86 0.653833
R882 VIN.n1369 VIN.n42 1.8005
R883 VIN.n1368 VIN.n597 1.99019
R884 VIN.n1369 VIN.n1368 0.214769
R885 VIN.n1367 VIN.n1369 0.214769
R886 VIN.n12 VIN.n1367 0.53751
R887 VIN.n1367 VIN.n1366 1.8005
R888 VIN.n68 VIN.n46 1.8005
R889 VIN.n294 VIN.n47 1.8005
R890 VIN.n74 VIN.n48 1.8005
R891 VIN.n328 VIN.n49 1.8005
R892 VIN.n80 VIN.n50 1.8005
R893 VIN.n85 VIN.n51 1.8005
R894 VIN.n590 VIN.n52 1.8005
R895 VIN.n594 VIN.n56 1.8005
R896 VIN.n1437 VIN.n43 5.8127
R897 VIN.n46 VIN.n43 0.3695
R898 VIN.n46 VIN.n45 0.0311
R899 VIN.n45 VIN.n1301 0.4001
R900 VIN.n1301 VIN.n1303 0.4001
R901 VIN.n47 VIN.n1303 0.3227
R902 VIN.n47 VIN.n1305 0.0779
R903 VIN.n1305 VIN.n1307 0.4001
R904 VIN.n1307 VIN.n1309 0.4001
R905 VIN.n48 VIN.n1309 0.2759
R906 VIN.n48 VIN.n1311 0.1247
R907 VIN.n1311 VIN.n1313 0.4001
R908 VIN.n1313 VIN.n1315 0.4001
R909 VIN.n49 VIN.n1315 0.2291
R910 VIN.n49 VIN.n1317 0.1715
R911 VIN.n1317 VIN.n1319 0.4001
R912 VIN.n1319 VIN.n1321 0.4001
R913 VIN.n50 VIN.n1321 0.1823
R914 VIN.n50 VIN.n1323 0.2183
R915 VIN.n1323 VIN.n1325 0.4001
R916 VIN.n1327 VIN.n1325 0.4001
R917 VIN.n51 VIN.n1327 0.1355
R918 VIN.n51 VIN.n1329 0.2651
R919 VIN.n1329 VIN.n1331 0.4001
R920 VIN.n1333 VIN.n1331 0.4001
R921 VIN.n52 VIN.n1333 0.0887
R922 VIN.n52 VIN.n1335 0.3119
R923 VIN.n1335 VIN.n1337 0.4001
R924 VIN.n1339 VIN.n1337 0.4001
R925 VIN.n53 VIN.n1339 0.0419
R926 VIN.n53 VIN.n1341 0.3587
R927 VIN.n1341 VIN.n1343 0.4001
R928 VIN.n56 VIN.n1343 0.3947
R929 VIN.n56 VIN.n1345 0.0059
R930 VIN.n1345 VIN.n1347 0.4001
R931 VIN.n1347 VIN.n1349 0.4001
R932 VIN.n57 VIN.n1349 0.3479
R933 VIN.n57 VIN.n1351 0.0527
R934 VIN.n1351 VIN.n1353 0.4001
R935 VIN.n1353 VIN.n1355 0.4001
R936 VIN.n1366 VIN.n1355 0.3011
R937 VIN.n1366 VIN.n1357 0.0995
R938 VIN.n1357 VIN.n1359 0.4001
R939 VIN.n1359 VIN.n1361 0.4001
R940 VIN.n1299 VIN.n1361 0.2543
R941 VIN.n1299 VIN.n1363 0.1463
R942 VIN.n1363 VIN.n1365 0.4001
R943 VIN.n1365 VIN.t131 7.02216
R944 VIN.n1365 VIN.n1364 5.96923
R945 VIN.n1364 VIN.t306 0.653833
R946 VIN.n1364 VIN.t305 0.653833
R947 VIN.n1363 VIN.n1362 5.96923
R948 VIN.n1362 VIN.t308 0.653833
R949 VIN.n1362 VIN.t307 0.653833
R950 VIN.n1361 VIN.n1360 5.96923
R951 VIN.n1360 VIN.t299 0.653833
R952 VIN.n1360 VIN.t298 0.653833
R953 VIN.n1359 VIN.n1358 5.96923
R954 VIN.n1358 VIN.t301 0.653833
R955 VIN.n1358 VIN.t300 0.653833
R956 VIN.n1357 VIN.n1356 5.96923
R957 VIN.n1356 VIN.t205 0.653833
R958 VIN.n1356 VIN.t204 0.653833
R959 VIN.n1355 VIN.n1354 5.96923
R960 VIN.n1354 VIN.t207 0.653833
R961 VIN.n1354 VIN.t206 0.653833
R962 VIN.n1353 VIN.n1352 5.96923
R963 VIN.n1352 VIN.t200 0.653833
R964 VIN.n1352 VIN.t199 0.653833
R965 VIN.n1351 VIN.n1350 5.96923
R966 VIN.n1350 VIN.t203 0.653833
R967 VIN.n1350 VIN.t201 0.653833
R968 VIN.n1349 VIN.n1348 5.96923
R969 VIN.n1348 VIN.t195 0.653833
R970 VIN.n1348 VIN.t194 0.653833
R971 VIN.n1347 VIN.n1346 5.96923
R972 VIN.n1346 VIN.t198 0.653833
R973 VIN.n1346 VIN.t196 0.653833
R974 VIN.n1345 VIN.n1344 5.96923
R975 VIN.n1344 VIN.t190 0.653833
R976 VIN.n1344 VIN.t188 0.653833
R977 VIN.n1343 VIN.n1342 5.96923
R978 VIN.n1342 VIN.t192 0.653833
R979 VIN.n1342 VIN.t191 0.653833
R980 VIN.n1341 VIN.n1340 5.96923
R981 VIN.n1340 VIN.t134 0.653833
R982 VIN.n1340 VIN.t132 0.653833
R983 VIN.n1339 VIN.n1338 5.96923
R984 VIN.n1338 VIN.t136 0.653833
R985 VIN.n1338 VIN.t135 0.653833
R986 VIN.n1337 VIN.n1336 5.96923
R987 VIN.n1336 VIN.t184 0.653833
R988 VIN.n1336 VIN.t182 0.653833
R989 VIN.n1335 VIN.n1334 5.96923
R990 VIN.n1334 VIN.t186 0.653833
R991 VIN.n1334 VIN.t185 0.653833
R992 VIN.n1333 VIN.n1332 5.96923
R993 VIN.n1332 VIN.t179 0.653833
R994 VIN.n1332 VIN.t178 0.653833
R995 VIN.n1331 VIN.n1330 5.96923
R996 VIN.n1330 VIN.t181 0.653833
R997 VIN.n1330 VIN.t180 0.653833
R998 VIN.n1329 VIN.n1328 5.96923
R999 VIN.n1328 VIN.t174 0.653833
R1000 VIN.n1328 VIN.t172 0.653833
R1001 VIN.n1327 VIN.n1326 5.96923
R1002 VIN.n1326 VIN.t177 0.653833
R1003 VIN.n1326 VIN.t176 0.653833
R1004 VIN.n1325 VIN.n1324 5.96923
R1005 VIN.n1324 VIN.t336 0.653833
R1006 VIN.n1324 VIN.t335 0.653833
R1007 VIN.n1323 VIN.n1322 5.96923
R1008 VIN.n1322 VIN.t338 0.653833
R1009 VIN.n1322 VIN.t337 0.653833
R1010 VIN.n1321 VIN.n1320 5.96923
R1011 VIN.n1320 VIN.t167 0.653833
R1012 VIN.n1320 VIN.t166 0.653833
R1013 VIN.n1319 VIN.n1318 5.96923
R1014 VIN.n1318 VIN.t170 0.653833
R1015 VIN.n1318 VIN.t168 0.653833
R1016 VIN.n1317 VIN.n1316 5.96923
R1017 VIN.n1316 VIN.t161 0.653833
R1018 VIN.n1316 VIN.t160 0.653833
R1019 VIN.n1315 VIN.n1314 5.96923
R1020 VIN.n1314 VIN.t165 0.653833
R1021 VIN.n1314 VIN.t163 0.653833
R1022 VIN.n1313 VIN.n1312 5.96923
R1023 VIN.n1312 VIN.t155 0.653833
R1024 VIN.n1312 VIN.t153 0.653833
R1025 VIN.n1311 VIN.n1310 5.96923
R1026 VIN.n1310 VIN.t158 0.653833
R1027 VIN.n1310 VIN.t156 0.653833
R1028 VIN.n1309 VIN.n1308 5.96923
R1029 VIN.n1308 VIN.t150 0.653833
R1030 VIN.n1308 VIN.t148 0.653833
R1031 VIN.n1307 VIN.n1306 5.96923
R1032 VIN.n1306 VIN.t152 0.653833
R1033 VIN.n1306 VIN.t151 0.653833
R1034 VIN.n1305 VIN.n1304 5.96923
R1035 VIN.n1304 VIN.t210 0.653833
R1036 VIN.n1304 VIN.t209 0.653833
R1037 VIN.n1303 VIN.n1302 5.96923
R1038 VIN.n1302 VIN.t212 0.653833
R1039 VIN.n1302 VIN.t211 0.653833
R1040 VIN.n1301 VIN.n1300 5.96923
R1041 VIN.n1300 VIN.t145 0.653833
R1042 VIN.n1300 VIN.t144 0.653833
R1043 VIN.n1298 VIN.n57 1.8005
R1044 VIN.n1296 VIN.n1297 0.214769
R1045 VIN.n1298 VIN.n1296 0.214769
R1046 VIN.n11 VIN.n1298 0.53751
R1047 VIN.n1297 VIN.n1295 1.99019
R1048 VIN.n58 VIN.n59 4.5005
R1049 VIN.n1092 VIN.n60 4.5005
R1050 VIN.n62 VIN.n61 4.5005
R1051 VIN.n64 VIN.n63 4.5005
R1052 VIN.n66 VIN.n65 4.5005
R1053 VIN.n72 VIN.n71 0.9005
R1054 VIN.n78 VIN.n77 0.9005
R1055 VIN.n84 VIN.n83 0.9005
R1056 VIN.n600 VIN.n599 4.5005
R1057 VIN.n602 VIN.n601 4.5005
R1058 VIN.n604 VIN.n603 4.5005
R1059 VIN.n606 VIN.n605 4.5005
R1060 VIN.n607 VIN.n608 4.5005
R1061 VIN.n609 VIN.n610 4.5005
R1062 VIN.n612 VIN.n611 4.5005
R1063 VIN.n614 VIN.n613 4.5005
R1064 VIN.n616 VIN.n615 4.5005
R1065 VIN.n618 VIN.n617 4.5005
R1066 VIN.n620 VIN.n619 4.5005
R1067 VIN.n621 VIN.n622 4.5005
R1068 VIN.n623 VIN.n624 4.5005
R1069 VIN.n625 VIN.n626 4.5005
R1070 VIN.n627 VIN.n628 4.5005
R1071 VIN.n630 VIN.n629 4.5005
R1072 VIN.n632 VIN.n631 4.5005
R1073 VIN.n634 VIN.n633 4.5005
R1074 VIN.n636 VIN.n635 4.5005
R1075 VIN.n637 VIN.n638 4.5005
R1076 VIN.n639 VIN.n640 4.5005
R1077 VIN.n641 VIN.n642 4.5005
R1078 VIN.n643 VIN.n644 4.5005
R1079 VIN.n646 VIN.n645 4.5005
R1080 VIN.n648 VIN.n647 4.5005
R1081 VIN.n650 VIN.n649 4.5005
R1082 VIN.n652 VIN.n651 4.5005
R1083 VIN.n654 VIN.n653 4.5005
R1084 VIN.n655 VIN.n656 4.5005
R1085 VIN.n657 VIN.n658 4.5005
R1086 VIN.n659 VIN.n660 4.5005
R1087 VIN.n662 VIN.n661 4.5005
R1088 VIN.n664 VIN.n663 4.5005
R1089 VIN.n666 VIN.n665 4.5005
R1090 VIN.n668 VIN.n667 4.5005
R1091 VIN.n670 VIN.n669 4.5005
R1092 VIN.n671 VIN.n672 4.5005
R1093 VIN.n673 VIN.n674 4.5005
R1094 VIN.n675 VIN.n676 4.5005
R1095 VIN.n677 VIN.n678 4.5005
R1096 VIN.n680 VIN.n679 4.5005
R1097 VIN.n682 VIN.n681 4.5005
R1098 VIN.n683 VIN.n684 4.5005
R1099 VIN.n685 VIN.n686 4.5005
R1100 VIN.n687 VIN.n688 4.5005
R1101 VIN.n689 VIN.n690 4.5005
R1102 VIN.n691 VIN.n692 4.5005
R1103 VIN.n693 VIN.n694 4.5005
R1104 VIN.n696 VIN.n695 4.5005
R1105 VIN.n698 VIN.n697 4.5005
R1106 VIN.n699 VIN.n700 4.5005
R1107 VIN.n701 VIN.n702 4.5005
R1108 VIN.n703 VIN.n704 4.5005
R1109 VIN.n705 VIN.n706 4.5005
R1110 VIN.n707 VIN.n708 4.5005
R1111 VIN.n709 VIN.n710 4.5005
R1112 VIN.n711 VIN.n712 4.5005
R1113 VIN.n713 VIN.n714 4.5005
R1114 VIN.n715 VIN.n716 4.5005
R1115 VIN.n717 VIN.n718 4.5005
R1116 VIN.n719 VIN.n720 4.5005
R1117 VIN.n722 VIN.n721 4.5005
R1118 VIN.n723 VIN.n724 4.5005
R1119 VIN.n725 VIN.n726 4.5005
R1120 VIN.n728 VIN.n727 4.5005
R1121 VIN.n730 VIN.n729 4.5005
R1122 VIN.n731 VIN.n732 4.5005
R1123 VIN.n733 VIN.n734 4.5005
R1124 VIN.n735 VIN.n736 4.5005
R1125 VIN.n737 VIN.n738 4.5005
R1126 VIN.n740 VIN.n739 4.5005
R1127 VIN.n741 VIN.n742 4.5005
R1128 VIN.n744 VIN.n743 4.5005
R1129 VIN.n746 VIN.n745 4.5005
R1130 VIN.n747 VIN.n748 4.5005
R1131 VIN.n749 VIN.n750 4.5005
R1132 VIN.n751 VIN.n752 4.5005
R1133 VIN.n753 VIN.n754 4.5005
R1134 VIN.n755 VIN.n756 4.5005
R1135 VIN.n757 VIN.n758 4.5005
R1136 VIN.n760 VIN.n759 4.5005
R1137 VIN.n762 VIN.n761 4.5005
R1138 VIN.n763 VIN.n764 4.5005
R1139 VIN.n766 VIN.n765 4.5005
R1140 VIN.n767 VIN.n768 4.5005
R1141 VIN.n769 VIN.n770 4.5005
R1142 VIN.n771 VIN.n772 4.5005
R1143 VIN.n773 VIN.n774 4.5005
R1144 VIN.n776 VIN.n775 4.5005
R1145 VIN.n778 VIN.n777 4.5005
R1146 VIN.n779 VIN.n780 4.5005
R1147 VIN.n781 VIN.n782 4.5005
R1148 VIN.n783 VIN.n784 4.5005
R1149 VIN.n785 VIN.n786 4.5005
R1150 VIN.n787 VIN.n788 4.5005
R1151 VIN.n62 VIN.n60 0.1445
R1152 VIN.n64 VIN.n62 0.1445
R1153 VIN.n66 VIN.n64 0.1445
R1154 VIN.n600 VIN.n66 0.1445
R1155 VIN.n67 VIN.n600 0.0572
R1156 VIN.n67 VIN.n602 0.0878
R1157 VIN.n602 VIN.n604 0.1445
R1158 VIN.n604 VIN.n606 0.1445
R1159 VIN.n606 VIN.n608 0.1445
R1160 VIN.n608 VIN.n610 0.1445
R1161 VIN.n612 VIN.n610 0.1445
R1162 VIN.n614 VIN.n612 0.1445
R1163 VIN.n616 VIN.n614 0.1445
R1164 VIN.n71 VIN.n616 0.0572
R1165 VIN.n71 VIN.n618 0.0878
R1166 VIN.n618 VIN.n620 0.1445
R1167 VIN.n620 VIN.n622 0.1445
R1168 VIN.n622 VIN.n624 0.1445
R1169 VIN.n624 VIN.n626 0.1445
R1170 VIN.n628 VIN.n626 0.1445
R1171 VIN.n630 VIN.n628 0.1445
R1172 VIN.n632 VIN.n630 0.1445
R1173 VIN.n73 VIN.n632 0.0572
R1174 VIN.n73 VIN.n634 0.0878
R1175 VIN.n634 VIN.n636 0.1445
R1176 VIN.n636 VIN.n638 0.1445
R1177 VIN.n638 VIN.n640 0.1445
R1178 VIN.n640 VIN.n642 0.1445
R1179 VIN.n644 VIN.n642 0.1445
R1180 VIN.n646 VIN.n644 0.1445
R1181 VIN.n648 VIN.n646 0.1445
R1182 VIN.n77 VIN.n648 0.0572
R1183 VIN.n77 VIN.n650 0.0878
R1184 VIN.n650 VIN.n652 0.1445
R1185 VIN.n652 VIN.n654 0.1445
R1186 VIN.n654 VIN.n656 0.1445
R1187 VIN.n656 VIN.n658 0.1445
R1188 VIN.n660 VIN.n658 0.1445
R1189 VIN.n662 VIN.n660 0.1445
R1190 VIN.n664 VIN.n662 0.1445
R1191 VIN.n79 VIN.n664 0.0572
R1192 VIN.n79 VIN.n666 0.0878
R1193 VIN.n666 VIN.n668 0.1445
R1194 VIN.n668 VIN.n670 0.1445
R1195 VIN.n670 VIN.n672 0.1445
R1196 VIN.n672 VIN.n674 0.1445
R1197 VIN.n676 VIN.n674 0.1445
R1198 VIN.n678 VIN.n676 0.1445
R1199 VIN.n680 VIN.n678 0.1445
R1200 VIN.n83 VIN.n680 0.0572
R1201 VIN.n83 VIN.n682 0.0878
R1202 VIN.n682 VIN.n684 0.1445
R1203 VIN.n684 VIN.n686 0.1445
R1204 VIN.n686 VIN.n688 0.1445
R1205 VIN.n688 VIN.n690 0.1445
R1206 VIN.n692 VIN.n690 0.1445
R1207 VIN.n694 VIN.n692 0.1445
R1208 VIN.n696 VIN.n694 0.1445
R1209 VIN.n589 VIN.n696 0.0572
R1210 VIN.n589 VIN.n698 0.0878
R1211 VIN.n698 VIN.n700 0.1445
R1212 VIN.n700 VIN.n702 0.1445
R1213 VIN.n702 VIN.n704 0.1445
R1214 VIN.n704 VIN.n706 0.1445
R1215 VIN.n706 VIN.n708 0.1445
R1216 VIN.n708 VIN.n710 0.1445
R1217 VIN.n710 VIN.n712 0.1445
R1218 VIN.n712 VIN.n714 0.1445
R1219 VIN.n716 VIN.n714 0.1445
R1220 VIN.n718 VIN.n716 0.1445
R1221 VIN.n720 VIN.n718 0.1445
R1222 VIN.n722 VIN.n720 0.1445
R1223 VIN.n724 VIN.n722 0.1445
R1224 VIN.n726 VIN.n724 0.1445
R1225 VIN.n728 VIN.n726 0.1445
R1226 VIN.n593 VIN.n728 0.0572
R1227 VIN.n593 VIN.n730 0.0878
R1228 VIN.n730 VIN.n732 0.1445
R1229 VIN.n732 VIN.n734 0.1445
R1230 VIN.n734 VIN.n736 0.1445
R1231 VIN.n736 VIN.n738 0.1445
R1232 VIN.n740 VIN.n738 0.1445
R1233 VIN.n742 VIN.n740 0.1445
R1234 VIN.n744 VIN.n742 0.1445
R1235 VIN.n1295 VIN.n744 0.0572
R1236 VIN.n1295 VIN.n746 0.0878
R1237 VIN.n746 VIN.n748 0.1445
R1238 VIN.n748 VIN.n750 0.1445
R1239 VIN.n750 VIN.n752 0.1445
R1240 VIN.n752 VIN.n754 0.1445
R1241 VIN.n756 VIN.n754 0.1445
R1242 VIN.n758 VIN.n756 0.1445
R1243 VIN.n760 VIN.n758 0.1445
R1244 VIN.n597 VIN.n760 0.0572
R1245 VIN.n597 VIN.n762 0.0878
R1246 VIN.n762 VIN.n764 0.1445
R1247 VIN.n764 VIN.n766 0.1445
R1248 VIN.n766 VIN.n768 0.1445
R1249 VIN.n768 VIN.n770 0.1445
R1250 VIN.n772 VIN.n770 0.1445
R1251 VIN.n774 VIN.n772 0.1445
R1252 VIN.n776 VIN.n774 0.1445
R1253 VIN.n598 VIN.n776 0.0572
R1254 VIN.n598 VIN.n778 0.0878
R1255 VIN.n778 VIN.n780 0.1445
R1256 VIN.n780 VIN.n782 0.1445
R1257 VIN.n782 VIN.n784 0.1445
R1258 VIN.n784 VIN.n786 0.1445
R1259 VIN.n786 VIN.n788 0.1445
R1260 VIN.n788 VIN.n59 0.1445
R1261 VIN.n791 VIN.n790 0.162038
R1262 VIN.n59 VIN.n791 6.66199
R1263 VIN.n791 VIN.n990 6.66199
R1264 VIN.n793 VIN.n792 4.5005
R1265 VIN.n795 VIN.n794 4.5005
R1266 VIN.n797 VIN.n796 4.5005
R1267 VIN.n799 VIN.n798 4.5005
R1268 VIN.n801 VIN.n800 4.5005
R1269 VIN.n803 VIN.n802 4.5005
R1270 VIN.n805 VIN.n804 4.5005
R1271 VIN.n807 VIN.n806 4.5005
R1272 VIN.n808 VIN.n809 4.5005
R1273 VIN.n810 VIN.n811 4.5005
R1274 VIN.n813 VIN.n812 4.5005
R1275 VIN.n814 VIN.n815 4.5005
R1276 VIN.n816 VIN.n817 4.5005
R1277 VIN.n818 VIN.n819 4.5005
R1278 VIN.n820 VIN.n821 4.5005
R1279 VIN.n822 VIN.n823 4.5005
R1280 VIN.n824 VIN.n825 4.5005
R1281 VIN.n826 VIN.n827 4.5005
R1282 VIN.n828 VIN.n829 4.5005
R1283 VIN.n830 VIN.n831 4.5005
R1284 VIN.n832 VIN.n833 4.5005
R1285 VIN.n834 VIN.n835 4.5005
R1286 VIN.n836 VIN.n837 4.5005
R1287 VIN.n838 VIN.n839 4.5005
R1288 VIN.n840 VIN.n841 4.5005
R1289 VIN.n842 VIN.n843 4.5005
R1290 VIN.n844 VIN.n845 4.5005
R1291 VIN.n847 VIN.n846 4.5005
R1292 VIN.n849 VIN.n848 4.5005
R1293 VIN.n851 VIN.n850 4.5005
R1294 VIN.n853 VIN.n852 4.5005
R1295 VIN.n855 VIN.n854 4.5005
R1296 VIN.n857 VIN.n856 4.5005
R1297 VIN.n859 VIN.n858 4.5005
R1298 VIN.n861 VIN.n860 4.5005
R1299 VIN.n863 VIN.n862 4.5005
R1300 VIN.n865 VIN.n864 4.5005
R1301 VIN.n867 VIN.n866 4.5005
R1302 VIN.n869 VIN.n868 4.5005
R1303 VIN.n870 VIN.n871 4.5005
R1304 VIN.n873 VIN.n872 4.5005
R1305 VIN.n875 VIN.n874 4.5005
R1306 VIN.n877 VIN.n876 4.5005
R1307 VIN.n879 VIN.n878 4.5005
R1308 VIN.n881 VIN.n880 4.5005
R1309 VIN.n882 VIN.n883 4.5005
R1310 VIN.n885 VIN.n884 4.5005
R1311 VIN.n886 VIN.n887 4.5005
R1312 VIN.n888 VIN.n889 4.5005
R1313 VIN.n891 VIN.n890 4.5005
R1314 VIN.n893 VIN.n892 4.5005
R1315 VIN.n895 VIN.n894 4.5005
R1316 VIN.n897 VIN.n896 4.5005
R1317 VIN.n898 VIN.n899 4.5005
R1318 VIN.n901 VIN.n900 4.5005
R1319 VIN.n903 VIN.n902 4.5005
R1320 VIN.n905 VIN.n904 4.5005
R1321 VIN.n907 VIN.n906 4.5005
R1322 VIN.n909 VIN.n908 4.5005
R1323 VIN.n911 VIN.n910 4.5005
R1324 VIN.n913 VIN.n912 4.5005
R1325 VIN.n915 VIN.n914 4.5005
R1326 VIN.n917 VIN.n916 4.5005
R1327 VIN.n919 VIN.n918 4.5005
R1328 VIN.n921 VIN.n920 4.5005
R1329 VIN.n922 VIN.n923 4.5005
R1330 VIN.n925 VIN.n924 4.5005
R1331 VIN.n927 VIN.n926 4.5005
R1332 VIN.n929 VIN.n928 4.5005
R1333 VIN.n931 VIN.n930 4.5005
R1334 VIN.n933 VIN.n932 4.5005
R1335 VIN.n935 VIN.n934 4.5005
R1336 VIN.n937 VIN.n936 4.5005
R1337 VIN.n939 VIN.n938 4.5005
R1338 VIN.n941 VIN.n940 4.5005
R1339 VIN.n943 VIN.n942 4.5005
R1340 VIN.n945 VIN.n944 4.5005
R1341 VIN.n947 VIN.n946 4.5005
R1342 VIN.n949 VIN.n948 4.5005
R1343 VIN.n950 VIN.n951 4.5005
R1344 VIN.n952 VIN.n953 4.5005
R1345 VIN.n954 VIN.n955 4.5005
R1346 VIN.n956 VIN.n957 4.5005
R1347 VIN.n958 VIN.n959 4.5005
R1348 VIN.n960 VIN.n961 4.5005
R1349 VIN.n962 VIN.n963 4.5005
R1350 VIN.n964 VIN.n965 4.5005
R1351 VIN.n966 VIN.n967 4.5005
R1352 VIN.n968 VIN.n969 4.5005
R1353 VIN.n970 VIN.n971 4.5005
R1354 VIN.n972 VIN.n973 4.5005
R1355 VIN.n974 VIN.n975 4.5005
R1356 VIN.n976 VIN.n977 4.5005
R1357 VIN.n978 VIN.n979 4.5005
R1358 VIN.n980 VIN.n981 4.5005
R1359 VIN.n982 VIN.n983 4.5005
R1360 VIN.n985 VIN.n984 4.5005
R1361 VIN.n986 VIN.n987 4.5005
R1362 VIN.n989 VIN.n988 4.5005
R1363 VIN.n990 VIN.n1292 4.5005
R1364 VIN.n793 VIN.n795 0.1445
R1365 VIN.n795 VIN.n797 0.1445
R1366 VIN.n797 VIN.n799 0.1445
R1367 VIN.n799 VIN.n801 0.1445
R1368 VIN.n801 VIN.n803 0.1445
R1369 VIN.n803 VIN.n805 0.1445
R1370 VIN.n805 VIN.n807 0.1445
R1371 VIN.n807 VIN.n809 0.1445
R1372 VIN.n809 VIN.n811 0.1445
R1373 VIN.n811 VIN.n813 0.1445
R1374 VIN.n813 VIN.n815 0.1445
R1375 VIN.n815 VIN.n817 0.1445
R1376 VIN.n817 VIN.n819 0.1445
R1377 VIN.n819 VIN.n821 0.1445
R1378 VIN.n821 VIN.n823 0.1445
R1379 VIN.n823 VIN.n825 0.1445
R1380 VIN.n825 VIN.n827 0.1445
R1381 VIN.n827 VIN.n829 0.1445
R1382 VIN.n829 VIN.n831 0.1445
R1383 VIN.n831 VIN.n833 0.1445
R1384 VIN.n833 VIN.n835 0.1445
R1385 VIN.n835 VIN.n837 0.1445
R1386 VIN.n837 VIN.n839 0.1445
R1387 VIN.n839 VIN.n841 0.1445
R1388 VIN.n841 VIN.n843 0.1445
R1389 VIN.n843 VIN.n845 0.1445
R1390 VIN.n845 VIN.n847 0.1445
R1391 VIN.n847 VIN.n849 0.1445
R1392 VIN.n849 VIN.n851 0.1445
R1393 VIN.n851 VIN.n853 0.1445
R1394 VIN.n853 VIN.n855 0.1445
R1395 VIN.n855 VIN.n857 0.1445
R1396 VIN.n857 VIN.n859 0.1445
R1397 VIN.n859 VIN.n861 0.1445
R1398 VIN.n861 VIN.n863 0.1445
R1399 VIN.n863 VIN.n865 0.1445
R1400 VIN.n865 VIN.n867 0.1445
R1401 VIN.n867 VIN.n869 0.1445
R1402 VIN.n869 VIN.n871 0.1445
R1403 VIN.n871 VIN.n873 0.1445
R1404 VIN.n873 VIN.n875 0.1445
R1405 VIN.n875 VIN.n877 0.1445
R1406 VIN.n877 VIN.n879 0.1445
R1407 VIN.n879 VIN.n881 0.1445
R1408 VIN.n881 VIN.n883 0.1445
R1409 VIN.n883 VIN.n885 0.1445
R1410 VIN.n885 VIN.n887 0.1445
R1411 VIN.n887 VIN.n889 0.1445
R1412 VIN.n889 VIN.n891 0.1445
R1413 VIN.n891 VIN.n893 0.1445
R1414 VIN.n893 VIN.n895 0.1445
R1415 VIN.n895 VIN.n897 0.1445
R1416 VIN.n897 VIN.n899 0.1445
R1417 VIN.n901 VIN.n899 0.1445
R1418 VIN.n903 VIN.n901 0.1445
R1419 VIN.n905 VIN.n903 0.1445
R1420 VIN.n907 VIN.n905 0.1445
R1421 VIN.n909 VIN.n907 0.1445
R1422 VIN.n911 VIN.n909 0.1445
R1423 VIN.n913 VIN.n911 0.1445
R1424 VIN.n915 VIN.n913 0.1445
R1425 VIN.n917 VIN.n915 0.1445
R1426 VIN.n919 VIN.n917 0.1445
R1427 VIN.n921 VIN.n919 0.1445
R1428 VIN.n923 VIN.n921 0.1445
R1429 VIN.n925 VIN.n923 0.1445
R1430 VIN.n927 VIN.n925 0.1445
R1431 VIN.n929 VIN.n927 0.1445
R1432 VIN.n931 VIN.n929 0.1445
R1433 VIN.n933 VIN.n931 0.1445
R1434 VIN.n935 VIN.n933 0.1445
R1435 VIN.n937 VIN.n935 0.1445
R1436 VIN.n939 VIN.n937 0.1445
R1437 VIN.n941 VIN.n939 0.1445
R1438 VIN.n943 VIN.n941 0.1445
R1439 VIN.n945 VIN.n943 0.1445
R1440 VIN.n947 VIN.n945 0.1445
R1441 VIN.n949 VIN.n947 0.1445
R1442 VIN.n951 VIN.n949 0.1445
R1443 VIN.n953 VIN.n951 0.1445
R1444 VIN.n955 VIN.n953 0.1445
R1445 VIN.n957 VIN.n955 0.1445
R1446 VIN.n959 VIN.n957 0.1445
R1447 VIN.n961 VIN.n959 0.1445
R1448 VIN.n963 VIN.n961 0.1445
R1449 VIN.n965 VIN.n963 0.1445
R1450 VIN.n967 VIN.n965 0.1445
R1451 VIN.n969 VIN.n967 0.1445
R1452 VIN.n971 VIN.n969 0.1445
R1453 VIN.n973 VIN.n971 0.1445
R1454 VIN.n975 VIN.n973 0.1445
R1455 VIN.n977 VIN.n975 0.1445
R1456 VIN.n979 VIN.n977 0.1445
R1457 VIN.n981 VIN.n979 0.1445
R1458 VIN.n983 VIN.n981 0.1445
R1459 VIN.n985 VIN.n983 0.1445
R1460 VIN.n987 VIN.n985 0.1445
R1461 VIN.n989 VIN.n987 0.1445
R1462 VIN.n990 VIN.n989 0.1445
R1463 VIN.n1294 VIN.n1293 0.162038
R1464 VIN.n1294 VIN.n793 6.66199
R1465 VIN.n60 VIN.n1294 6.66199
R1466 VIN.n992 VIN.n789 4.51881
R1467 VIN.n58 VIN.n992 6.3005
R1468 VIN.n993 VIN.n1288 6.3005
R1469 VIN.n787 VIN.n993 6.3005
R1470 VIN.n994 VIN.n1286 6.3005
R1471 VIN.n785 VIN.n994 6.3005
R1472 VIN.n995 VIN.n1284 6.3005
R1473 VIN.n783 VIN.n995 6.3005
R1474 VIN.n996 VIN.n1282 6.3005
R1475 VIN.n781 VIN.n996 6.3005
R1476 VIN.n997 VIN.n1280 6.3005
R1477 VIN.n779 VIN.n997 6.3005
R1478 VIN.n998 VIN.n1278 6.3005
R1479 VIN.n777 VIN.n998 6.3005
R1480 VIN.n999 VIN.n1276 6.3005
R1481 VIN.n775 VIN.n999 6.3005
R1482 VIN.n1000 VIN.n1274 6.3005
R1483 VIN.n773 VIN.n1000 6.3005
R1484 VIN.n1001 VIN.n1272 6.3005
R1485 VIN.n771 VIN.n1001 6.3005
R1486 VIN.n1002 VIN.n1270 6.3005
R1487 VIN.n769 VIN.n1002 6.3005
R1488 VIN.n1003 VIN.n1268 6.3005
R1489 VIN.n767 VIN.n1003 6.3005
R1490 VIN.n1004 VIN.n1266 6.3005
R1491 VIN.n765 VIN.n1004 6.3005
R1492 VIN.n1005 VIN.n1264 6.3005
R1493 VIN.n763 VIN.n1005 6.3005
R1494 VIN.n1006 VIN.n1262 6.3005
R1495 VIN.n761 VIN.n1006 6.3005
R1496 VIN.n1007 VIN.n1260 6.3005
R1497 VIN.n759 VIN.n1007 6.3005
R1498 VIN.n1008 VIN.t41 6.3005
R1499 VIN.n757 VIN.n1008 6.3005
R1500 VIN.n1009 VIN.n1257 6.3005
R1501 VIN.n755 VIN.n1009 6.3005
R1502 VIN.n1010 VIN.n1255 6.3005
R1503 VIN.n753 VIN.n1010 6.3005
R1504 VIN.n1011 VIN.n1253 6.3005
R1505 VIN.n751 VIN.n1011 6.3005
R1506 VIN.n1012 VIN.n1251 6.3005
R1507 VIN.n749 VIN.n1012 6.3005
R1508 VIN.n1013 VIN.n1249 6.3005
R1509 VIN.n747 VIN.n1013 6.3005
R1510 VIN.n1014 VIN.n1247 6.3005
R1511 VIN.n745 VIN.n1014 6.3005
R1512 VIN.n1015 VIN.n1245 6.3005
R1513 VIN.n743 VIN.n1015 6.3005
R1514 VIN.n1016 VIN.n1243 6.3005
R1515 VIN.n741 VIN.n1016 6.3005
R1516 VIN.n1017 VIN.n1241 6.3005
R1517 VIN.n739 VIN.n1017 6.3005
R1518 VIN.n1018 VIN.n1239 6.3005
R1519 VIN.n737 VIN.n1018 6.3005
R1520 VIN.n1019 VIN.n1237 6.3005
R1521 VIN.n735 VIN.n1019 6.3005
R1522 VIN.n1020 VIN.n1235 6.3005
R1523 VIN.n733 VIN.n1020 6.3005
R1524 VIN.n1021 VIN.n1233 6.3005
R1525 VIN.n731 VIN.n1021 6.3005
R1526 VIN.n1022 VIN.n1231 6.3005
R1527 VIN.n729 VIN.n1022 6.3005
R1528 VIN.n1023 VIN.n1229 6.3005
R1529 VIN.n727 VIN.n1023 6.3005
R1530 VIN.n1024 VIN.n1227 6.3005
R1531 VIN.n725 VIN.n1024 6.3005
R1532 VIN.n1025 VIN.n1225 6.3005
R1533 VIN.n723 VIN.n1025 6.3005
R1534 VIN.n1026 VIN.n1223 6.3005
R1535 VIN.n721 VIN.n1026 6.3005
R1536 VIN.n1027 VIN.n1221 6.3005
R1537 VIN.n719 VIN.n1027 6.3005
R1538 VIN.n1028 VIN.n1219 6.3005
R1539 VIN.n717 VIN.n1028 6.3005
R1540 VIN.n1029 VIN.n1217 6.3005
R1541 VIN.n715 VIN.n1029 6.3005
R1542 VIN.n1030 VIN.n1215 6.3005
R1543 VIN.n713 VIN.n1030 6.3005
R1544 VIN.n1031 VIN.n1213 6.3005
R1545 VIN.n711 VIN.n1031 6.3005
R1546 VIN.n1032 VIN.n1211 6.3005
R1547 VIN.n709 VIN.n1032 6.3005
R1548 VIN.n1033 VIN.n1209 6.3005
R1549 VIN.n707 VIN.n1033 6.3005
R1550 VIN.n1034 VIN.n1207 6.3005
R1551 VIN.n705 VIN.n1034 6.3005
R1552 VIN.n1035 VIN.n1205 6.3005
R1553 VIN.n703 VIN.n1035 6.3005
R1554 VIN.n1036 VIN.n1203 6.3005
R1555 VIN.n701 VIN.n1036 6.3005
R1556 VIN.n1037 VIN.n1201 6.3005
R1557 VIN.n699 VIN.n1037 6.3005
R1558 VIN.n1038 VIN.n1199 6.3005
R1559 VIN.n697 VIN.n1038 6.3005
R1560 VIN.n1039 VIN.n1197 6.3005
R1561 VIN.n695 VIN.n1039 6.3005
R1562 VIN.n1040 VIN.n1195 6.3005
R1563 VIN.n693 VIN.n1040 6.3005
R1564 VIN.n1041 VIN.n1193 6.3005
R1565 VIN.n691 VIN.n1041 6.3005
R1566 VIN.n1042 VIN.n1191 6.3005
R1567 VIN.n689 VIN.n1042 6.3005
R1568 VIN.n1043 VIN.n1189 6.3005
R1569 VIN.n687 VIN.n1043 6.3005
R1570 VIN.n1044 VIN.n1187 6.3005
R1571 VIN.n685 VIN.n1044 6.3005
R1572 VIN.n1045 VIN.n1185 6.3005
R1573 VIN.n683 VIN.n1045 6.3005
R1574 VIN.n1046 VIN.n1183 6.3005
R1575 VIN.n681 VIN.n1046 6.3005
R1576 VIN.n1047 VIN.n1181 6.3005
R1577 VIN.n679 VIN.n1047 6.3005
R1578 VIN.n1048 VIN.n1179 6.3005
R1579 VIN.n677 VIN.n1048 6.3005
R1580 VIN.n1049 VIN.n1177 6.3005
R1581 VIN.n675 VIN.n1049 6.3005
R1582 VIN.n1050 VIN.n1175 6.3005
R1583 VIN.n673 VIN.n1050 6.3005
R1584 VIN.n1051 VIN.n1173 6.3005
R1585 VIN.n671 VIN.n1051 6.3005
R1586 VIN.n1052 VIN.n1171 6.3005
R1587 VIN.n669 VIN.n1052 6.3005
R1588 VIN.n1053 VIN.n1169 6.3005
R1589 VIN.n667 VIN.n1053 6.3005
R1590 VIN.n1054 VIN.n1167 6.3005
R1591 VIN.n665 VIN.n1054 6.3005
R1592 VIN.n1055 VIN.n1165 6.3005
R1593 VIN.n663 VIN.n1055 6.3005
R1594 VIN.n1056 VIN.n1163 6.3005
R1595 VIN.n661 VIN.n1056 6.3005
R1596 VIN.n1057 VIN.n1161 6.3005
R1597 VIN.n659 VIN.n1057 6.3005
R1598 VIN.n1058 VIN.n1159 6.3005
R1599 VIN.n657 VIN.n1058 6.3005
R1600 VIN.n1059 VIN.n1157 6.3005
R1601 VIN.n655 VIN.n1059 6.3005
R1602 VIN.n1060 VIN.n1155 6.3005
R1603 VIN.n653 VIN.n1060 6.3005
R1604 VIN.n1061 VIN.n1153 6.3005
R1605 VIN.n651 VIN.n1061 6.3005
R1606 VIN.n1062 VIN.n1151 6.3005
R1607 VIN.n649 VIN.n1062 6.3005
R1608 VIN.n1063 VIN.n1149 6.3005
R1609 VIN.n647 VIN.n1063 6.3005
R1610 VIN.n1064 VIN.n1147 6.3005
R1611 VIN.n645 VIN.n1064 6.3005
R1612 VIN.n1065 VIN.n1145 6.3005
R1613 VIN.n643 VIN.n1065 6.3005
R1614 VIN.n1066 VIN.n1143 6.3005
R1615 VIN.n641 VIN.n1066 6.3005
R1616 VIN.n1067 VIN.n1141 6.3005
R1617 VIN.n639 VIN.n1067 6.3005
R1618 VIN.n1068 VIN.n1139 6.3005
R1619 VIN.n637 VIN.n1068 6.3005
R1620 VIN.n1069 VIN.n1137 6.3005
R1621 VIN.n635 VIN.n1069 6.3005
R1622 VIN.n1070 VIN.n1135 6.3005
R1623 VIN.n633 VIN.n1070 6.3005
R1624 VIN.n1071 VIN.n1133 6.3005
R1625 VIN.n631 VIN.n1071 6.3005
R1626 VIN.n1072 VIN.n1131 6.3005
R1627 VIN.n629 VIN.n1072 6.3005
R1628 VIN.n1073 VIN.n1129 6.3005
R1629 VIN.n627 VIN.n1073 6.3005
R1630 VIN.n1074 VIN.n1127 6.3005
R1631 VIN.n625 VIN.n1074 6.3005
R1632 VIN.n1075 VIN.n1125 6.3005
R1633 VIN.n623 VIN.n1075 6.3005
R1634 VIN.n1076 VIN.n1123 6.3005
R1635 VIN.n621 VIN.n1076 6.3005
R1636 VIN.n1077 VIN.n1121 6.3005
R1637 VIN.n619 VIN.n1077 6.3005
R1638 VIN.n1078 VIN.n1119 6.3005
R1639 VIN.n617 VIN.n1078 6.3005
R1640 VIN.n1079 VIN.n1117 6.3005
R1641 VIN.n615 VIN.n1079 6.3005
R1642 VIN.n1080 VIN.n1115 6.3005
R1643 VIN.n613 VIN.n1080 6.3005
R1644 VIN.n1081 VIN.n1113 6.3005
R1645 VIN.n611 VIN.n1081 6.3005
R1646 VIN.n1082 VIN.n1111 6.3005
R1647 VIN.n609 VIN.n1082 6.3005
R1648 VIN.n1083 VIN.n1109 6.3005
R1649 VIN.n607 VIN.n1083 6.3005
R1650 VIN.n1084 VIN.n1107 6.3005
R1651 VIN.n605 VIN.n1084 6.3005
R1652 VIN.n1085 VIN.n1105 6.3005
R1653 VIN.n603 VIN.n1085 6.3005
R1654 VIN.n1086 VIN.n1103 6.3005
R1655 VIN.n601 VIN.n1086 6.3005
R1656 VIN.n1087 VIN.n1101 6.3005
R1657 VIN.n599 VIN.n1087 6.3005
R1658 VIN.n1088 VIN.n1099 6.3005
R1659 VIN.n65 VIN.n1088 6.3005
R1660 VIN.n1089 VIN.n1097 6.3005
R1661 VIN.n63 VIN.n1089 6.3005
R1662 VIN.n1090 VIN.n1095 6.3005
R1663 VIN.n61 VIN.n1090 6.3005
R1664 VIN.n991 VIN.n1093 1.6356
R1665 VIN.n1092 VIN.n1091 6.3005
R1666 VIN.n1091 VIN.n991 4.51881
R1667 VIN.n1091 VIN.n1090 14.0005
R1668 VIN.n1090 VIN.n1089 14.0005
R1669 VIN.n1089 VIN.n1088 14.0005
R1670 VIN.n1088 VIN.n1087 14.0005
R1671 VIN.n1087 VIN.n1086 14.0005
R1672 VIN.n1086 VIN.n1085 14.0005
R1673 VIN.n1085 VIN.n1084 14.0005
R1674 VIN.n1084 VIN.n1083 14.0005
R1675 VIN.n1083 VIN.n1082 14.0005
R1676 VIN.n1082 VIN.n1081 14.0005
R1677 VIN.n1081 VIN.n1080 14.0005
R1678 VIN.n1080 VIN.n1079 14.0005
R1679 VIN.n1079 VIN.n1078 14.0005
R1680 VIN.n1078 VIN.n1077 14.0005
R1681 VIN.n1077 VIN.n1076 14.0005
R1682 VIN.n1076 VIN.n1075 14.0005
R1683 VIN.n1075 VIN.n1074 14.0005
R1684 VIN.n1074 VIN.n1073 14.0005
R1685 VIN.n1073 VIN.n1072 14.0005
R1686 VIN.n1072 VIN.n1071 14.0005
R1687 VIN.n1071 VIN.n1070 14.0005
R1688 VIN.n1070 VIN.n1069 14.0005
R1689 VIN.n1069 VIN.n1068 14.0005
R1690 VIN.n1068 VIN.n1067 14.0005
R1691 VIN.n1067 VIN.n1066 14.0005
R1692 VIN.n1066 VIN.n1065 14.0005
R1693 VIN.n1065 VIN.n1064 14.0005
R1694 VIN.n1064 VIN.n1063 14.0005
R1695 VIN.n1063 VIN.n1062 14.0005
R1696 VIN.n1062 VIN.n1061 14.0005
R1697 VIN.n1061 VIN.n1060 14.0005
R1698 VIN.n1060 VIN.n1059 14.0005
R1699 VIN.n1059 VIN.n1058 14.0005
R1700 VIN.n1058 VIN.n1057 14.0005
R1701 VIN.n1057 VIN.n1056 14.0005
R1702 VIN.n1056 VIN.n1055 14.0005
R1703 VIN.n1055 VIN.n1054 14.0005
R1704 VIN.n1054 VIN.n1053 14.0005
R1705 VIN.n1053 VIN.n1052 14.0005
R1706 VIN.n1052 VIN.n1051 14.0005
R1707 VIN.n1051 VIN.n1050 14.0005
R1708 VIN.n1050 VIN.n1049 14.0005
R1709 VIN.n1049 VIN.n1048 14.0005
R1710 VIN.n1048 VIN.n1047 14.0005
R1711 VIN.n1047 VIN.n1046 14.0005
R1712 VIN.n1046 VIN.n1045 14.0005
R1713 VIN.n1045 VIN.n1044 14.0005
R1714 VIN.n1044 VIN.n1043 14.0005
R1715 VIN.n1043 VIN.n1042 14.0005
R1716 VIN.n1042 VIN.n1041 14.0005
R1717 VIN.n1041 VIN.n1040 14.0005
R1718 VIN.n1040 VIN.n1039 14.0005
R1719 VIN.n1039 VIN.n1038 14.0005
R1720 VIN.n1038 VIN.n1037 14.0005
R1721 VIN.n1037 VIN.n1036 14.0005
R1722 VIN.n1036 VIN.n1035 14.0005
R1723 VIN.n1035 VIN.n1034 14.0005
R1724 VIN.n1034 VIN.n1033 14.0005
R1725 VIN.n1033 VIN.n1032 14.0005
R1726 VIN.n1032 VIN.n1031 14.0005
R1727 VIN.n1031 VIN.n1030 14.0005
R1728 VIN.n1030 VIN.n1029 14.0005
R1729 VIN.n1029 VIN.n1028 14.0005
R1730 VIN.n1028 VIN.n1027 14.0005
R1731 VIN.n1027 VIN.n1026 14.0005
R1732 VIN.n1026 VIN.n1025 14.0005
R1733 VIN.n1025 VIN.n1024 14.0005
R1734 VIN.n1024 VIN.n1023 14.0005
R1735 VIN.n1023 VIN.n1022 14.0005
R1736 VIN.n1022 VIN.n1021 14.0005
R1737 VIN.n1021 VIN.n1020 14.0005
R1738 VIN.n1020 VIN.n1019 14.0005
R1739 VIN.n1019 VIN.n1018 14.0005
R1740 VIN.n1018 VIN.n1017 14.0005
R1741 VIN.n1017 VIN.n1016 14.0005
R1742 VIN.n1016 VIN.n1015 14.0005
R1743 VIN.n1015 VIN.n1014 14.0005
R1744 VIN.n1014 VIN.n1013 14.0005
R1745 VIN.n1013 VIN.n1012 14.0005
R1746 VIN.n1012 VIN.n1011 14.0005
R1747 VIN.n1011 VIN.n1010 14.0005
R1748 VIN.n1010 VIN.n1009 14.0005
R1749 VIN.n1009 VIN.n1008 14.0005
R1750 VIN.n1008 VIN.n1007 14.0005
R1751 VIN.n1007 VIN.n1006 14.0005
R1752 VIN.n1006 VIN.n1005 14.0005
R1753 VIN.n1005 VIN.n1004 14.0005
R1754 VIN.n1004 VIN.n1003 14.0005
R1755 VIN.n1003 VIN.n1002 14.0005
R1756 VIN.n1002 VIN.n1001 14.0005
R1757 VIN.n1001 VIN.n1000 14.0005
R1758 VIN.n1000 VIN.n999 14.0005
R1759 VIN.n999 VIN.n998 14.0005
R1760 VIN.n998 VIN.n997 14.0005
R1761 VIN.n997 VIN.n996 14.0005
R1762 VIN.n996 VIN.n995 14.0005
R1763 VIN.n995 VIN.n994 14.0005
R1764 VIN.n994 VIN.n993 14.0005
R1765 VIN.n993 VIN.n992 14.0005
R1766 VIN.n789 VIN.n790 50.038
R1767 VIN.n1093 VIN.n1094 6.3005
R1768 VIN.n1094 VIN.n792 6.3005
R1769 VIN.n1095 VIN.n1096 6.3005
R1770 VIN.n1096 VIN.n794 6.3005
R1771 VIN.n1097 VIN.n1098 6.3005
R1772 VIN.n1098 VIN.n796 6.3005
R1773 VIN.n1099 VIN.n1100 6.3005
R1774 VIN.n1100 VIN.n798 6.3005
R1775 VIN.n1101 VIN.n1102 6.3005
R1776 VIN.n1102 VIN.n800 6.3005
R1777 VIN.n1103 VIN.n1104 6.3005
R1778 VIN.n1104 VIN.n802 6.3005
R1779 VIN.n1105 VIN.n1106 6.3005
R1780 VIN.n1106 VIN.n804 6.3005
R1781 VIN.n1107 VIN.n1108 6.3005
R1782 VIN.n1108 VIN.n806 6.3005
R1783 VIN.n1109 VIN.n1110 6.3005
R1784 VIN.n1110 VIN.n808 6.3005
R1785 VIN.n1111 VIN.n1112 6.3005
R1786 VIN.n1112 VIN.n810 6.3005
R1787 VIN.n1113 VIN.n1114 6.3005
R1788 VIN.n1114 VIN.n812 6.3005
R1789 VIN.n1115 VIN.n1116 6.3005
R1790 VIN.n1116 VIN.n814 6.3005
R1791 VIN.n1117 VIN.n1118 6.3005
R1792 VIN.n1118 VIN.n816 6.3005
R1793 VIN.n1119 VIN.n1120 6.3005
R1794 VIN.n1120 VIN.n818 6.3005
R1795 VIN.n1121 VIN.n1122 6.3005
R1796 VIN.n1122 VIN.n820 6.3005
R1797 VIN.n1123 VIN.n1124 6.3005
R1798 VIN.n1124 VIN.n822 6.3005
R1799 VIN.n1125 VIN.n1126 6.3005
R1800 VIN.n1126 VIN.n824 6.3005
R1801 VIN.n1127 VIN.n1128 6.3005
R1802 VIN.n1128 VIN.n826 6.3005
R1803 VIN.n1129 VIN.n1130 6.3005
R1804 VIN.n1130 VIN.n828 6.3005
R1805 VIN.n1131 VIN.n1132 6.3005
R1806 VIN.n1132 VIN.n830 6.3005
R1807 VIN.n1133 VIN.n1134 6.3005
R1808 VIN.n1134 VIN.n832 6.3005
R1809 VIN.n1135 VIN.n1136 6.3005
R1810 VIN.n1136 VIN.n834 6.3005
R1811 VIN.n1137 VIN.n1138 6.3005
R1812 VIN.n1138 VIN.n836 6.3005
R1813 VIN.n1139 VIN.n1140 6.3005
R1814 VIN.n1140 VIN.n838 6.3005
R1815 VIN.n1141 VIN.n1142 6.3005
R1816 VIN.n1142 VIN.n840 6.3005
R1817 VIN.n1143 VIN.n1144 6.3005
R1818 VIN.n1144 VIN.n842 6.3005
R1819 VIN.n1145 VIN.n1146 6.3005
R1820 VIN.n1146 VIN.n844 6.3005
R1821 VIN.n1147 VIN.n1148 6.3005
R1822 VIN.n1148 VIN.n846 6.3005
R1823 VIN.n1149 VIN.n1150 6.3005
R1824 VIN.n1150 VIN.n848 6.3005
R1825 VIN.n1151 VIN.n1152 6.3005
R1826 VIN.n1152 VIN.n850 6.3005
R1827 VIN.n1153 VIN.n1154 6.3005
R1828 VIN.n1154 VIN.n852 6.3005
R1829 VIN.n1155 VIN.n1156 6.3005
R1830 VIN.n1156 VIN.n854 6.3005
R1831 VIN.n1157 VIN.n1158 6.3005
R1832 VIN.n1158 VIN.n856 6.3005
R1833 VIN.n1159 VIN.n1160 6.3005
R1834 VIN.n1160 VIN.n858 6.3005
R1835 VIN.n1161 VIN.n1162 6.3005
R1836 VIN.n1162 VIN.n860 6.3005
R1837 VIN.n1163 VIN.n1164 6.3005
R1838 VIN.n1164 VIN.n862 6.3005
R1839 VIN.n1165 VIN.n1166 6.3005
R1840 VIN.n1166 VIN.n864 6.3005
R1841 VIN.n1167 VIN.n1168 6.3005
R1842 VIN.n1168 VIN.n866 6.3005
R1843 VIN.n1169 VIN.n1170 6.3005
R1844 VIN.n1170 VIN.n868 6.3005
R1845 VIN.n1171 VIN.n1172 6.3005
R1846 VIN.n1172 VIN.n870 6.3005
R1847 VIN.n1173 VIN.n1174 6.3005
R1848 VIN.n1174 VIN.n872 6.3005
R1849 VIN.n1175 VIN.n1176 6.3005
R1850 VIN.n1176 VIN.n874 6.3005
R1851 VIN.n1177 VIN.n1178 6.3005
R1852 VIN.n1178 VIN.n876 6.3005
R1853 VIN.n1179 VIN.n1180 6.3005
R1854 VIN.n1180 VIN.n878 6.3005
R1855 VIN.n1181 VIN.n1182 6.3005
R1856 VIN.n1182 VIN.n880 6.3005
R1857 VIN.n1183 VIN.n1184 6.3005
R1858 VIN.n1184 VIN.n882 6.3005
R1859 VIN.n1185 VIN.n1186 6.3005
R1860 VIN.n1186 VIN.n884 6.3005
R1861 VIN.n1187 VIN.n1188 6.3005
R1862 VIN.n1188 VIN.n886 6.3005
R1863 VIN.n1189 VIN.n1190 6.3005
R1864 VIN.n1190 VIN.n888 6.3005
R1865 VIN.n1191 VIN.n1192 6.3005
R1866 VIN.n1192 VIN.n890 6.3005
R1867 VIN.n1193 VIN.n1194 6.3005
R1868 VIN.n1194 VIN.n892 6.3005
R1869 VIN.n1195 VIN.n1196 6.3005
R1870 VIN.n1196 VIN.n894 6.3005
R1871 VIN.n1197 VIN.n1198 6.3005
R1872 VIN.n1198 VIN.n896 6.3005
R1873 VIN.n1199 VIN.n1200 6.3005
R1874 VIN.n1200 VIN.n898 6.3005
R1875 VIN.n1201 VIN.n1202 6.3005
R1876 VIN.n1202 VIN.n900 6.3005
R1877 VIN.n1203 VIN.n1204 6.3005
R1878 VIN.n1204 VIN.n902 6.3005
R1879 VIN.n1205 VIN.n1206 6.3005
R1880 VIN.n1206 VIN.n904 6.3005
R1881 VIN.n1207 VIN.n1208 6.3005
R1882 VIN.n1208 VIN.n906 6.3005
R1883 VIN.n1209 VIN.n1210 6.3005
R1884 VIN.n1210 VIN.n908 6.3005
R1885 VIN.n1211 VIN.n1212 6.3005
R1886 VIN.n1212 VIN.n910 6.3005
R1887 VIN.n1213 VIN.n1214 6.3005
R1888 VIN.n1214 VIN.n912 6.3005
R1889 VIN.n1215 VIN.n1216 6.3005
R1890 VIN.n1216 VIN.n914 6.3005
R1891 VIN.n1217 VIN.n1218 6.3005
R1892 VIN.n1218 VIN.n916 6.3005
R1893 VIN.n1219 VIN.n1220 6.3005
R1894 VIN.n1220 VIN.n918 6.3005
R1895 VIN.n1221 VIN.n1222 6.3005
R1896 VIN.n1222 VIN.n920 6.3005
R1897 VIN.n1223 VIN.n1224 6.3005
R1898 VIN.n1224 VIN.n922 6.3005
R1899 VIN.n1225 VIN.n1226 6.3005
R1900 VIN.n1226 VIN.n924 6.3005
R1901 VIN.n1227 VIN.n1228 6.3005
R1902 VIN.n1228 VIN.n926 6.3005
R1903 VIN.n1229 VIN.n1230 6.3005
R1904 VIN.n1230 VIN.n928 6.3005
R1905 VIN.n1231 VIN.n1232 6.3005
R1906 VIN.n1232 VIN.n930 6.3005
R1907 VIN.n1233 VIN.n1234 6.3005
R1908 VIN.n1234 VIN.n932 6.3005
R1909 VIN.n1235 VIN.n1236 6.3005
R1910 VIN.n1236 VIN.n934 6.3005
R1911 VIN.n1237 VIN.n1238 6.3005
R1912 VIN.n1238 VIN.n936 6.3005
R1913 VIN.n1239 VIN.n1240 6.3005
R1914 VIN.n1240 VIN.n938 6.3005
R1915 VIN.n1241 VIN.n1242 6.3005
R1916 VIN.n1242 VIN.n940 6.3005
R1917 VIN.n1243 VIN.n1244 6.3005
R1918 VIN.n1244 VIN.n942 6.3005
R1919 VIN.n1245 VIN.n1246 6.3005
R1920 VIN.n1246 VIN.n944 6.3005
R1921 VIN.n1247 VIN.n1248 6.3005
R1922 VIN.n1248 VIN.n946 6.3005
R1923 VIN.n1249 VIN.n1250 6.3005
R1924 VIN.n1250 VIN.n948 6.3005
R1925 VIN.n1251 VIN.n1252 6.3005
R1926 VIN.n1252 VIN.n950 6.3005
R1927 VIN.n1253 VIN.n1254 6.3005
R1928 VIN.n1254 VIN.n952 6.3005
R1929 VIN.n1255 VIN.n1256 6.3005
R1930 VIN.n1256 VIN.n954 6.3005
R1931 VIN.n1257 VIN.n1258 6.3005
R1932 VIN.n1258 VIN.n956 6.3005
R1933 VIN.t41 VIN.n1259 6.3005
R1934 VIN.n1259 VIN.n958 6.3005
R1935 VIN.n1260 VIN.n1261 6.3005
R1936 VIN.n1261 VIN.n960 6.3005
R1937 VIN.n1262 VIN.n1263 6.3005
R1938 VIN.n1263 VIN.n962 6.3005
R1939 VIN.n1264 VIN.n1265 6.3005
R1940 VIN.n1265 VIN.n964 6.3005
R1941 VIN.n1266 VIN.n1267 6.3005
R1942 VIN.n1267 VIN.n966 6.3005
R1943 VIN.n1268 VIN.n1269 6.3005
R1944 VIN.n1269 VIN.n968 6.3005
R1945 VIN.n1270 VIN.n1271 6.3005
R1946 VIN.n1271 VIN.n970 6.3005
R1947 VIN.n1272 VIN.n1273 6.3005
R1948 VIN.n1273 VIN.n972 6.3005
R1949 VIN.n1274 VIN.n1275 6.3005
R1950 VIN.n1275 VIN.n974 6.3005
R1951 VIN.n1276 VIN.n1277 6.3005
R1952 VIN.n1277 VIN.n976 6.3005
R1953 VIN.n1278 VIN.n1279 6.3005
R1954 VIN.n1279 VIN.n978 6.3005
R1955 VIN.n1280 VIN.n1281 6.3005
R1956 VIN.n1281 VIN.n980 6.3005
R1957 VIN.n1282 VIN.n1283 6.3005
R1958 VIN.n1283 VIN.n982 6.3005
R1959 VIN.n1284 VIN.n1285 6.3005
R1960 VIN.n1285 VIN.n984 6.3005
R1961 VIN.n1286 VIN.n1287 6.3005
R1962 VIN.n1287 VIN.n986 6.3005
R1963 VIN.n1288 VIN.n1289 6.3005
R1964 VIN.n1289 VIN.n988 6.3005
R1965 VIN.n1290 VIN.n1291 6.3005
R1966 VIN.n1291 VIN.n1292 6.3005
R1967 VIN.n1293 VIN.n1094 192.851
R1968 VIN.n1094 VIN.n1096 14.0005
R1969 VIN.n1096 VIN.n1098 14.0005
R1970 VIN.n1098 VIN.n1100 14.0005
R1971 VIN.n1100 VIN.n1102 14.0005
R1972 VIN.n1102 VIN.n1104 14.0005
R1973 VIN.n1104 VIN.n1106 14.0005
R1974 VIN.n1106 VIN.n1108 14.0005
R1975 VIN.n1108 VIN.n1110 14.0005
R1976 VIN.n1110 VIN.n1112 14.0005
R1977 VIN.n1112 VIN.n1114 14.0005
R1978 VIN.n1114 VIN.n1116 14.0005
R1979 VIN.n1116 VIN.n1118 14.0005
R1980 VIN.n1118 VIN.n1120 14.0005
R1981 VIN.n1120 VIN.n1122 14.0005
R1982 VIN.n1122 VIN.n1124 14.0005
R1983 VIN.n1124 VIN.n1126 14.0005
R1984 VIN.n1126 VIN.n1128 14.0005
R1985 VIN.n1128 VIN.n1130 14.0005
R1986 VIN.n1130 VIN.n1132 14.0005
R1987 VIN.n1132 VIN.n1134 14.0005
R1988 VIN.n1134 VIN.n1136 14.0005
R1989 VIN.n1136 VIN.n1138 14.0005
R1990 VIN.n1138 VIN.n1140 14.0005
R1991 VIN.n1140 VIN.n1142 14.0005
R1992 VIN.n1142 VIN.n1144 14.0005
R1993 VIN.n1144 VIN.n1146 14.0005
R1994 VIN.n1146 VIN.n1148 14.0005
R1995 VIN.n1148 VIN.n1150 14.0005
R1996 VIN.n1150 VIN.n1152 14.0005
R1997 VIN.n1152 VIN.n1154 14.0005
R1998 VIN.n1154 VIN.n1156 14.0005
R1999 VIN.n1156 VIN.n1158 14.0005
R2000 VIN.n1158 VIN.n1160 14.0005
R2001 VIN.n1160 VIN.n1162 14.0005
R2002 VIN.n1162 VIN.n1164 14.0005
R2003 VIN.n1164 VIN.n1166 14.0005
R2004 VIN.n1166 VIN.n1168 14.0005
R2005 VIN.n1168 VIN.n1170 14.0005
R2006 VIN.n1170 VIN.n1172 14.0005
R2007 VIN.n1172 VIN.n1174 14.0005
R2008 VIN.n1174 VIN.n1176 14.0005
R2009 VIN.n1176 VIN.n1178 14.0005
R2010 VIN.n1178 VIN.n1180 14.0005
R2011 VIN.n1180 VIN.n1182 14.0005
R2012 VIN.n1182 VIN.n1184 14.0005
R2013 VIN.n1184 VIN.n1186 14.0005
R2014 VIN.n1186 VIN.n1188 14.0005
R2015 VIN.n1188 VIN.n1190 14.0005
R2016 VIN.n1190 VIN.n1192 14.0005
R2017 VIN.n1192 VIN.n1194 14.0005
R2018 VIN.n1194 VIN.n1196 14.0005
R2019 VIN.n1196 VIN.n1198 14.0005
R2020 VIN.n1198 VIN.n1200 14.0005
R2021 VIN.n1200 VIN.n1202 14.0005
R2022 VIN.n1202 VIN.n1204 14.0005
R2023 VIN.n1204 VIN.n1206 14.0005
R2024 VIN.n1206 VIN.n1208 14.0005
R2025 VIN.n1208 VIN.n1210 14.0005
R2026 VIN.n1210 VIN.n1212 14.0005
R2027 VIN.n1212 VIN.n1214 14.0005
R2028 VIN.n1214 VIN.n1216 14.0005
R2029 VIN.n1216 VIN.n1218 14.0005
R2030 VIN.n1218 VIN.n1220 14.0005
R2031 VIN.n1220 VIN.n1222 14.0005
R2032 VIN.n1222 VIN.n1224 14.0005
R2033 VIN.n1224 VIN.n1226 14.0005
R2034 VIN.n1226 VIN.n1228 14.0005
R2035 VIN.n1228 VIN.n1230 14.0005
R2036 VIN.n1230 VIN.n1232 14.0005
R2037 VIN.n1232 VIN.n1234 14.0005
R2038 VIN.n1234 VIN.n1236 14.0005
R2039 VIN.n1236 VIN.n1238 14.0005
R2040 VIN.n1238 VIN.n1240 14.0005
R2041 VIN.n1240 VIN.n1242 14.0005
R2042 VIN.n1242 VIN.n1244 14.0005
R2043 VIN.n1244 VIN.n1246 14.0005
R2044 VIN.n1246 VIN.n1248 14.0005
R2045 VIN.n1248 VIN.n1250 14.0005
R2046 VIN.n1250 VIN.n1252 14.0005
R2047 VIN.n1252 VIN.n1254 14.0005
R2048 VIN.n1254 VIN.n1256 14.0005
R2049 VIN.n1256 VIN.n1258 14.0005
R2050 VIN.n1258 VIN.n1259 14.0005
R2051 VIN.n1259 VIN.n1261 14.0005
R2052 VIN.n1261 VIN.n1263 14.0005
R2053 VIN.n1263 VIN.n1265 14.0005
R2054 VIN.n1265 VIN.n1267 14.0005
R2055 VIN.n1267 VIN.n1269 14.0005
R2056 VIN.n1269 VIN.n1271 14.0005
R2057 VIN.n1271 VIN.n1273 14.0005
R2058 VIN.n1273 VIN.n1275 14.0005
R2059 VIN.n1275 VIN.n1277 14.0005
R2060 VIN.n1277 VIN.n1279 14.0005
R2061 VIN.n1279 VIN.n1281 14.0005
R2062 VIN.n1281 VIN.n1283 14.0005
R2063 VIN.n1283 VIN.n1285 14.0005
R2064 VIN.n1285 VIN.n1287 14.0005
R2065 VIN.n1287 VIN.n1289 14.0005
R2066 VIN.n1289 VIN.n1291 14.0005
R2067 VIN.n1291 VIN.n790 192.851
R2068 VIN.n792 VIN.n794 0.1445
R2069 VIN.n794 VIN.n796 0.1445
R2070 VIN.n796 VIN.n798 0.1445
R2071 VIN.n798 VIN.n800 0.1445
R2072 VIN.n800 VIN.n802 0.1445
R2073 VIN.n802 VIN.n804 0.1445
R2074 VIN.n804 VIN.n806 0.1445
R2075 VIN.n806 VIN.n808 0.1445
R2076 VIN.n808 VIN.n810 0.1445
R2077 VIN.n810 VIN.n812 0.1445
R2078 VIN.n812 VIN.n814 0.1445
R2079 VIN.n814 VIN.n816 0.1445
R2080 VIN.n816 VIN.n818 0.1445
R2081 VIN.n818 VIN.n820 0.1445
R2082 VIN.n820 VIN.n822 0.1445
R2083 VIN.n822 VIN.n824 0.1445
R2084 VIN.n824 VIN.n826 0.1445
R2085 VIN.n826 VIN.n828 0.1445
R2086 VIN.n828 VIN.n830 0.1445
R2087 VIN.n830 VIN.n832 0.1445
R2088 VIN.n832 VIN.n834 0.1445
R2089 VIN.n834 VIN.n836 0.1445
R2090 VIN.n836 VIN.n838 0.1445
R2091 VIN.n838 VIN.n840 0.1445
R2092 VIN.n840 VIN.n842 0.1445
R2093 VIN.n842 VIN.n844 0.1445
R2094 VIN.n844 VIN.n846 0.1445
R2095 VIN.n846 VIN.n848 0.1445
R2096 VIN.n848 VIN.n850 0.1445
R2097 VIN.n850 VIN.n852 0.1445
R2098 VIN.n852 VIN.n854 0.1445
R2099 VIN.n854 VIN.n856 0.1445
R2100 VIN.n856 VIN.n858 0.1445
R2101 VIN.n858 VIN.n860 0.1445
R2102 VIN.n860 VIN.n862 0.1445
R2103 VIN.n862 VIN.n864 0.1445
R2104 VIN.n864 VIN.n866 0.1445
R2105 VIN.n866 VIN.n868 0.1445
R2106 VIN.n868 VIN.n870 0.1445
R2107 VIN.n870 VIN.n872 0.1445
R2108 VIN.n872 VIN.n874 0.1445
R2109 VIN.n874 VIN.n876 0.1445
R2110 VIN.n876 VIN.n878 0.1445
R2111 VIN.n878 VIN.n880 0.1445
R2112 VIN.n880 VIN.n882 0.1445
R2113 VIN.n882 VIN.n884 0.1445
R2114 VIN.n884 VIN.n886 0.1445
R2115 VIN.n886 VIN.n888 0.1445
R2116 VIN.n888 VIN.n890 0.1445
R2117 VIN.n890 VIN.n892 0.1445
R2118 VIN.n892 VIN.n894 0.1445
R2119 VIN.n894 VIN.n896 0.1445
R2120 VIN.n896 VIN.n898 0.1445
R2121 VIN.n900 VIN.n898 0.1445
R2122 VIN.n900 VIN.n902 0.1445
R2123 VIN.n902 VIN.n904 0.1445
R2124 VIN.n904 VIN.n906 0.1445
R2125 VIN.n906 VIN.n908 0.1445
R2126 VIN.n908 VIN.n910 0.1445
R2127 VIN.n910 VIN.n912 0.1445
R2128 VIN.n912 VIN.n914 0.1445
R2129 VIN.n914 VIN.n916 0.1445
R2130 VIN.n916 VIN.n918 0.1445
R2131 VIN.n918 VIN.n920 0.1445
R2132 VIN.n920 VIN.n922 0.1445
R2133 VIN.n924 VIN.n922 0.1445
R2134 VIN.n924 VIN.n926 0.1445
R2135 VIN.n926 VIN.n928 0.1445
R2136 VIN.n928 VIN.n930 0.1445
R2137 VIN.n930 VIN.n932 0.1445
R2138 VIN.n932 VIN.n934 0.1445
R2139 VIN.n934 VIN.n936 0.1445
R2140 VIN.n936 VIN.n938 0.1445
R2141 VIN.n938 VIN.n940 0.1445
R2142 VIN.n940 VIN.n942 0.1445
R2143 VIN.n942 VIN.n944 0.1445
R2144 VIN.n944 VIN.n946 0.1445
R2145 VIN.n946 VIN.n948 0.1445
R2146 VIN.n948 VIN.n950 0.1445
R2147 VIN.n952 VIN.n950 0.1445
R2148 VIN.n954 VIN.n952 0.1445
R2149 VIN.n956 VIN.n954 0.1445
R2150 VIN.n958 VIN.n956 0.1445
R2151 VIN.n960 VIN.n958 0.1445
R2152 VIN.n962 VIN.n960 0.1445
R2153 VIN.n964 VIN.n962 0.1445
R2154 VIN.n966 VIN.n964 0.1445
R2155 VIN.n968 VIN.n966 0.1445
R2156 VIN.n970 VIN.n968 0.1445
R2157 VIN.n972 VIN.n970 0.1445
R2158 VIN.n974 VIN.n972 0.1445
R2159 VIN.n976 VIN.n974 0.1445
R2160 VIN.n978 VIN.n976 0.1445
R2161 VIN.n980 VIN.n978 0.1445
R2162 VIN.n982 VIN.n980 0.1445
R2163 VIN.n984 VIN.n982 0.1445
R2164 VIN.n984 VIN.n986 0.1445
R2165 VIN.n988 VIN.n986 0.1445
R2166 VIN.n988 VIN.n1292 0.1445
R2167 VIN.n1293 VIN.n991 50.038
R2168 VIN.n1093 VIN.n1095 39.0821
R2169 VIN.n1095 VIN.n1097 39.0821
R2170 VIN.n1097 VIN.t129 20.5183
R2171 VIN.n1099 VIN.t129 18.5643
R2172 VIN.n1099 VIN.t127 35.6624
R2173 VIN.n1101 VIN.t127 3.42014
R2174 VIN.n1101 VIN.n1103 39.0821
R2175 VIN.n1103 VIN.t125 11.725
R2176 VIN.t125 VIN.n1105 27.3576
R2177 VIN.n1105 VIN.t87 26.8691
R2178 VIN.n1107 VIN.t87 12.2135
R2179 VIN.n1107 VIN.n1109 39.0821
R2180 VIN.n1109 VIN.t85 2.93162
R2181 VIN.t85 VIN.n1111 36.151
R2182 VIN.n1111 VIN.t83 18.0757
R2183 VIN.t83 VIN.n1113 21.0069
R2184 VIN.n1113 VIN.t6 33.2198
R2185 VIN.n1115 VIN.t6 5.86274
R2186 VIN.n1115 VIN.n1117 39.0821
R2187 VIN.n1117 VIN.t75 9.28238
R2188 VIN.t75 VIN.n1119 29.8002
R2189 VIN.n1119 VIN.t91 24.4265
R2190 VIN.n1121 VIN.t91 14.6561
R2191 VIN.n1121 VIN.n1123 39.0821
R2192 VIN.n1123 VIN.t109 0.48902
R2193 VIN.t109 VIN.n1125 38.5936
R2194 VIN.n1125 VIN.t107 15.6331
R2195 VIN.t107 VIN.n1127 23.4494
R2196 VIN.n1127 VIN.t149 30.7772
R2197 VIN.n1129 VIN.t149 8.30534
R2198 VIN.n1129 VIN.n1131 39.0821
R2199 VIN.n1131 VIN.t89 6.83978
R2200 VIN.t89 VIN.n1133 32.2428
R2201 VIN.n1133 VIN.t157 21.9839
R2202 VIN.n1135 VIN.t157 17.0987
R2203 VIN.n1135 VIN.t26 37.128
R2204 VIN.n1137 VIN.t26 1.95458
R2205 VIN.n1137 VIN.n1139 39.0821
R2206 VIN.n1139 VIN.t154 13.1905
R2207 VIN.t154 VIN.n1141 25.892
R2208 VIN.n1141 VIN.t100 28.3346
R2209 VIN.n1143 VIN.t100 10.7479
R2210 VIN.n1143 VIN.n1145 39.0821
R2211 VIN.n1145 VIN.t164 4.39718
R2212 VIN.t164 VIN.n1147 34.6854
R2213 VIN.n1147 VIN.t162 19.5413
R2214 VIN.n1149 VIN.t162 19.5413
R2215 VIN.n1149 VIN.t98 34.6854
R2216 VIN.n1151 VIN.t98 4.39718
R2217 VIN.n1151 VIN.n1153 39.0821
R2218 VIN.n1153 VIN.t159 10.7479
R2219 VIN.t159 VIN.n1155 28.3346
R2220 VIN.n1155 VIN.t169 25.892
R2221 VIN.n1157 VIN.t169 13.1905
R2222 VIN.n1157 VIN.n1159 39.0821
R2223 VIN.n1159 VIN.t17 1.95458
R2224 VIN.t17 VIN.n1161 37.128
R2225 VIN.n1161 VIN.t114 17.0987
R2226 VIN.t114 VIN.n1163 21.9839
R2227 VIN.n1163 VIN.t51 32.2428
R2228 VIN.n1165 VIN.t51 6.83978
R2229 VIN.n1165 VIN.n1167 39.0821
R2230 VIN.n1167 VIN.t319 8.30534
R2231 VIN.t319 VIN.n1169 30.7772
R2232 VIN.n1169 VIN.t28 23.4494
R2233 VIN.n1171 VIN.t28 15.6331
R2234 VIN.n1171 VIN.t105 38.5936
R2235 VIN.n1173 VIN.t105 0.48902
R2236 VIN.n1173 VIN.n1175 39.0821
R2237 VIN.n1175 VIN.t290 14.6561
R2238 VIN.t290 VIN.n1177 24.4265
R2239 VIN.n1177 VIN.t95 29.8002
R2240 VIN.n1179 VIN.t95 9.28238
R2241 VIN.n1179 VIN.n1181 39.0821
R2242 VIN.n1181 VIN.t175 5.86274
R2243 VIN.t175 VIN.n1183 33.2198
R2244 VIN.n1183 VIN.t173 21.0069
R2245 VIN.n1185 VIN.t173 18.0757
R2246 VIN.n1185 VIN.t171 36.151
R2247 VIN.n1187 VIN.t171 2.93162
R2248 VIN.n1187 VIN.n1189 39.0821
R2249 VIN.n1189 VIN.t73 12.2135
R2250 VIN.t73 VIN.n1191 26.8691
R2251 VIN.n1191 VIN.t138 27.3576
R2252 VIN.n1193 VIN.t138 11.725
R2253 VIN.n1193 VIN.n1195 39.0821
R2254 VIN.n1195 VIN.t71 3.42014
R2255 VIN.t71 VIN.n1197 35.6624
R2256 VIN.n1197 VIN.t36 18.5643
R2257 VIN.t36 VIN.n1199 20.5183
R2258 VIN.n1199 VIN.t32 33.7084
R2259 VIN.n1201 VIN.t32 5.37422
R2260 VIN.n1201 VIN.n1203 39.0821
R2261 VIN.n1203 VIN.t45 9.7709
R2262 VIN.t45 VIN.n1205 29.3117
R2263 VIN.n1205 VIN.t183 24.915
R2264 VIN.n1207 VIN.t183 14.1676
R2265 VIN.n1207 VIN.n1209 39.0821
R2266 VIN.n1209 VIN.t63 0.97754
R2267 VIN.t63 VIN.n1211 38.105
R2268 VIN.n1211 VIN.t77 16.1217
R2269 VIN.t77 VIN.n1213 22.9609
R2270 VIN.n1213 VIN.t102 31.2658
R2271 VIN.n1215 VIN.t102 7.81682
R2272 VIN.n1215 VIN.n1217 39.0821
R2273 VIN.n1217 VIN.t133 7.3283
R2274 VIN.t133 VIN.n1219 31.7543
R2275 VIN.n1219 VIN.t118 22.4724
R2276 VIN.n1221 VIN.t118 16.6102
R2277 VIN.n1221 VIN.t30 37.6165
R2278 VIN.n1223 VIN.t30 1.46606
R2279 VIN.n1223 VIN.n1225 39.0821
R2280 VIN.n1225 VIN.t12 13.6791
R2281 VIN.t12 VIN.n1227 25.4035
R2282 VIN.n1227 VIN.t189 28.8232
R2283 VIN.n1229 VIN.t189 10.2594
R2284 VIN.n1229 VIN.n1231 39.0821
R2285 VIN.n1231 VIN.t187 4.8857
R2286 VIN.t187 VIN.n1233 34.1969
R2287 VIN.n1233 VIN.t197 20.0298
R2288 VIN.n1235 VIN.t197 19.0528
R2289 VIN.n1235 VIN.t48 35.1739
R2290 VIN.n1237 VIN.t48 3.90866
R2291 VIN.n1237 VIN.n1239 39.0821
R2292 VIN.n1239 VIN.t2 11.2365
R2293 VIN.t2 VIN.n1241 27.8461
R2294 VIN.n1241 VIN.t193 26.3806
R2295 VIN.n1243 VIN.t193 12.702
R2296 VIN.n1243 VIN.n1245 39.0821
R2297 VIN.n1245 VIN.t202 2.4431
R2298 VIN.t202 VIN.n1247 36.6395
R2299 VIN.n1247 VIN.t15 17.5872
R2300 VIN.t15 VIN.n1249 21.4954
R2301 VIN.n1249 VIN.t24 32.7313
R2302 VIN.n1251 VIN.t24 6.35126
R2303 VIN.n1251 VIN.n1253 39.0821
R2304 VIN.n1253 VIN.t61 8.79386
R2305 VIN.t61 VIN.n1255 30.2887
R2306 VIN.n1255 VIN.t4 23.938
R2307 VIN.n1257 VIN.t4 15.1446
R2308 VIN.n1257 VIN.t41 39.0821
R2309 VIN.t41 VIN.n1260 39.0821
R2310 VIN.n1260 VIN.t10 15.1446
R2311 VIN.t10 VIN.n1262 23.938
R2312 VIN.n1262 VIN.t43 30.2887
R2313 VIN.n1264 VIN.t43 8.79386
R2314 VIN.n1264 VIN.n1266 39.0821
R2315 VIN.n1266 VIN.t122 6.35126
R2316 VIN.t122 VIN.n1268 32.7313
R2317 VIN.n1268 VIN.t93 21.4954
R2318 VIN.n1270 VIN.t93 17.5872
R2319 VIN.n1270 VIN.t20 36.6395
R2320 VIN.n1272 VIN.t20 2.4431
R2321 VIN.n1272 VIN.n1274 39.0821
R2322 VIN.n1274 VIN.t0 12.702
R2323 VIN.t0 VIN.n1276 26.3806
R2324 VIN.n1276 VIN.t120 27.8461
R2325 VIN.n1278 VIN.t120 11.2365
R2326 VIN.n1278 VIN.n1280 39.0821
R2327 VIN.n1280 VIN.t8 3.90866
R2328 VIN.t8 VIN.n1282 35.1739
R2329 VIN.n1282 VIN.t58 19.0528
R2330 VIN.t58 VIN.n1284 20.0298
R2331 VIN.n1284 VIN.t53 34.1969
R2332 VIN.n1286 VIN.t53 4.8857
R2333 VIN.n1286 VIN.n1288 39.0821
R2334 VIN.n1288 VIN.t39 10.2594
R2335 VIN.t39 VIN.n1290 28.8232
R2336 VIN.n789 VIN.n1290 1.6356
R2337 VIN.n61 VIN.n1092 0.1445
R2338 VIN.n61 VIN.n63 0.1445
R2339 VIN.n63 VIN.n65 0.1445
R2340 VIN.n65 VIN.n599 0.1445
R2341 VIN.n599 VIN.n601 0.1445
R2342 VIN.n601 VIN.n603 0.1445
R2343 VIN.n603 VIN.n605 0.1445
R2344 VIN.n605 VIN.n607 0.1445
R2345 VIN.n607 VIN.n609 0.1445
R2346 VIN.n611 VIN.n609 0.1445
R2347 VIN.n611 VIN.n613 0.1445
R2348 VIN.n613 VIN.n615 0.1445
R2349 VIN.n615 VIN.n617 0.1445
R2350 VIN.n617 VIN.n619 0.1445
R2351 VIN.n619 VIN.n621 0.1445
R2352 VIN.n621 VIN.n623 0.1445
R2353 VIN.n623 VIN.n625 0.1445
R2354 VIN.n627 VIN.n625 0.1445
R2355 VIN.n629 VIN.n627 0.1445
R2356 VIN.n629 VIN.n631 0.1445
R2357 VIN.n631 VIN.n633 0.1445
R2358 VIN.n633 VIN.n635 0.1445
R2359 VIN.n635 VIN.n637 0.1445
R2360 VIN.n637 VIN.n639 0.1445
R2361 VIN.n639 VIN.n641 0.1445
R2362 VIN.n643 VIN.n641 0.1445
R2363 VIN.n645 VIN.n643 0.1445
R2364 VIN.n645 VIN.n647 0.1445
R2365 VIN.n647 VIN.n649 0.1445
R2366 VIN.n649 VIN.n651 0.1445
R2367 VIN.n651 VIN.n653 0.1445
R2368 VIN.n653 VIN.n655 0.1445
R2369 VIN.n655 VIN.n657 0.1445
R2370 VIN.n659 VIN.n657 0.1445
R2371 VIN.n661 VIN.n659 0.1445
R2372 VIN.n661 VIN.n663 0.1445
R2373 VIN.n663 VIN.n665 0.1445
R2374 VIN.n665 VIN.n667 0.1445
R2375 VIN.n667 VIN.n669 0.1445
R2376 VIN.n669 VIN.n671 0.1445
R2377 VIN.n671 VIN.n673 0.1445
R2378 VIN.n675 VIN.n673 0.1445
R2379 VIN.n677 VIN.n675 0.1445
R2380 VIN.n679 VIN.n677 0.1445
R2381 VIN.n679 VIN.n681 0.1445
R2382 VIN.n681 VIN.n683 0.1445
R2383 VIN.n683 VIN.n685 0.1445
R2384 VIN.n685 VIN.n687 0.1445
R2385 VIN.n687 VIN.n689 0.1445
R2386 VIN.n691 VIN.n689 0.1445
R2387 VIN.n693 VIN.n691 0.1445
R2388 VIN.n695 VIN.n693 0.1445
R2389 VIN.n695 VIN.n697 0.1445
R2390 VIN.n697 VIN.n699 0.1445
R2391 VIN.n699 VIN.n701 0.1445
R2392 VIN.n701 VIN.n703 0.1445
R2393 VIN.n703 VIN.n705 0.1445
R2394 VIN.n705 VIN.n707 0.1445
R2395 VIN.n707 VIN.n709 0.1445
R2396 VIN.n709 VIN.n711 0.1445
R2397 VIN.n711 VIN.n713 0.1445
R2398 VIN.n715 VIN.n713 0.1445
R2399 VIN.n717 VIN.n715 0.1445
R2400 VIN.n719 VIN.n717 0.1445
R2401 VIN.n721 VIN.n719 0.1445
R2402 VIN.n721 VIN.n723 0.1445
R2403 VIN.n725 VIN.n723 0.1445
R2404 VIN.n727 VIN.n725 0.1445
R2405 VIN.n727 VIN.n729 0.1445
R2406 VIN.n729 VIN.n731 0.1445
R2407 VIN.n731 VIN.n733 0.1445
R2408 VIN.n733 VIN.n735 0.1445
R2409 VIN.n735 VIN.n737 0.1445
R2410 VIN.n739 VIN.n737 0.1445
R2411 VIN.n739 VIN.n741 0.1445
R2412 VIN.n743 VIN.n741 0.1445
R2413 VIN.n743 VIN.n745 0.1445
R2414 VIN.n745 VIN.n747 0.1445
R2415 VIN.n747 VIN.n749 0.1445
R2416 VIN.n749 VIN.n751 0.1445
R2417 VIN.n751 VIN.n753 0.1445
R2418 VIN.n755 VIN.n753 0.1445
R2419 VIN.n757 VIN.n755 0.1445
R2420 VIN.n759 VIN.n757 0.1445
R2421 VIN.n759 VIN.n761 0.1445
R2422 VIN.n761 VIN.n763 0.1445
R2423 VIN.n763 VIN.n765 0.1445
R2424 VIN.n765 VIN.n767 0.1445
R2425 VIN.n767 VIN.n769 0.1445
R2426 VIN.n771 VIN.n769 0.1445
R2427 VIN.n773 VIN.n771 0.1445
R2428 VIN.n775 VIN.n773 0.1445
R2429 VIN.n775 VIN.n777 0.1445
R2430 VIN.n777 VIN.n779 0.1445
R2431 VIN.n779 VIN.n781 0.1445
R2432 VIN.n781 VIN.n783 0.1445
R2433 VIN.n783 VIN.n785 0.1445
R2434 VIN.n785 VIN.n787 0.1445
R2435 VIN.n787 VIN.n58 0.1445
R2436 VIN.n596 VIN.n593 1.99019
R2437 VIN.n595 VIN.n596 0.214769
R2438 VIN.n594 VIN.n595 0.214769
R2439 VIN.n10 VIN.n594 0.53751
R2440 VIN.n592 VIN.n589 1.99019
R2441 VIN.n591 VIN.n592 0.214769
R2442 VIN.n590 VIN.n591 0.214769
R2443 VIN.n8 VIN.n590 0.53751
R2444 VIN.n84 VIN.n588 5.02925
R2445 VIN.n89 VIN.n88 4.5005
R2446 VIN.n588 VIN.n89 0.0165
R2447 VIN.n91 VIN.n90 4.5005
R2448 VIN.n93 VIN.n92 4.5005
R2449 VIN.n95 VIN.n94 4.5005
R2450 VIN.n96 VIN.n97 4.5005
R2451 VIN.n98 VIN.n99 4.5005
R2452 VIN.n100 VIN.n101 4.5005
R2453 VIN.n102 VIN.n103 4.5005
R2454 VIN.n104 VIN.n105 4.5005
R2455 VIN.n106 VIN.n107 4.5005
R2456 VIN.n108 VIN.n109 4.5005
R2457 VIN.n111 VIN.n110 4.5005
R2458 VIN.n112 VIN.n113 4.5005
R2459 VIN.n115 VIN.n114 4.5005
R2460 VIN.n117 VIN.n116 4.5005
R2461 VIN.n119 VIN.n118 4.5005
R2462 VIN.n121 VIN.n120 4.5005
R2463 VIN.n123 VIN.n122 4.5005
R2464 VIN.n125 VIN.n124 4.5005
R2465 VIN.n127 VIN.n126 4.5005
R2466 VIN.n588 VIN.n93 0.0797
R2467 VIN.n93 VIN.n95 0.1445
R2468 VIN.n95 VIN.n97 0.1445
R2469 VIN.n97 VIN.n99 0.1445
R2470 VIN.n99 VIN.n101 0.1445
R2471 VIN.n101 VIN.n103 0.1445
R2472 VIN.n103 VIN.n105 0.1445
R2473 VIN.n105 VIN.n107 0.1445
R2474 VIN.n107 VIN.n109 0.1445
R2475 VIN.n109 VIN.n111 0.1445
R2476 VIN.n111 VIN.n113 0.1445
R2477 VIN.n113 VIN.n115 0.1445
R2478 VIN.n115 VIN.n117 0.1445
R2479 VIN.n117 VIN.n119 0.1445
R2480 VIN.n119 VIN.n121 0.1445
R2481 VIN.n121 VIN.n123 0.1445
R2482 VIN.n123 VIN.n125 0.1445
R2483 VIN.n125 VIN.n127 0.1445
R2484 VIN.n127 VIN.n91 0.1445
R2485 VIN.n129 VIN.n128 0.0974231
R2486 VIN.n129 VIN.n585 1.47767
R2487 VIN.n91 VIN.n129 7.9149
R2488 VIN.n587 VIN.n586 0.348761
R2489 VIN.n585 VIN.n587 2.13702
R2490 VIN.n586 VIN.t245 2.72428
R2491 VIN.n587 VIN.t246 2.37602
R2492 VIN.n586 VIN.t243 18.1872
R2493 VIN.n585 VIN.n130 0.266409
R2494 VIN.n130 VIN.n582 0.266409
R2495 VIN.n584 VIN.n583 0.348761
R2496 VIN.n582 VIN.n584 2.13702
R2497 VIN.n584 VIN.t253 2.37602
R2498 VIN.n583 VIN.t254 2.72428
R2499 VIN.n583 VIN.t252 18.1872
R2500 VIN.n582 VIN.n132 5.7099
R2501 VIN.n132 VIN.n131 4.5005
R2502 VIN.n133 VIN.n569 4.5005
R2503 VIN.n134 VIN.n135 4.5005
R2504 VIN.n136 VIN.n137 4.5005
R2505 VIN.n138 VIN.n139 4.5005
R2506 VIN.n140 VIN.n141 4.5005
R2507 VIN.n142 VIN.n143 4.5005
R2508 VIN.n144 VIN.n145 4.5005
R2509 VIN.n147 VIN.n146 4.5005
R2510 VIN.n148 VIN.n149 4.5005
R2511 VIN.n150 VIN.n151 4.5005
R2512 VIN.n152 VIN.n153 4.5005
R2513 VIN.n154 VIN.n155 4.5005
R2514 VIN.n156 VIN.n157 4.5005
R2515 VIN.n159 VIN.n158 4.5005
R2516 VIN.n160 VIN.n161 4.5005
R2517 VIN.n162 VIN.n163 4.5005
R2518 VIN.n164 VIN.n165 4.5005
R2519 VIN.n167 VIN.n166 4.5005
R2520 VIN.n168 VIN.n169 4.5005
R2521 VIN.n171 VIN.n170 4.5005
R2522 VIN.n173 VIN.n172 4.5005
R2523 VIN.n174 VIN.n175 4.5005
R2524 VIN.n176 VIN.n177 4.5005
R2525 VIN.n179 VIN.n178 4.5005
R2526 VIN.n180 VIN.n181 4.5005
R2527 VIN.n182 VIN.n183 4.5005
R2528 VIN.n184 VIN.n185 4.5005
R2529 VIN.n186 VIN.n187 4.5005
R2530 VIN.n188 VIN.n189 4.5005
R2531 VIN.n191 VIN.n190 4.5005
R2532 VIN.n193 VIN.n192 4.5005
R2533 VIN.n195 VIN.n194 4.5005
R2534 VIN.n197 VIN.n196 4.5005
R2535 VIN.n199 VIN.n198 4.5005
R2536 VIN.n201 VIN.n200 4.5005
R2537 VIN.n203 VIN.n202 4.5005
R2538 VIN.n205 VIN.n204 4.5005
R2539 VIN.n207 VIN.n206 4.5005
R2540 VIN.n209 VIN.n208 4.5005
R2541 VIN.n211 VIN.n210 4.5005
R2542 VIN.n213 VIN.n212 4.5005
R2543 VIN.n215 VIN.n214 4.5005
R2544 VIN.n217 VIN.n216 4.5005
R2545 VIN.n218 VIN.n219 4.5005
R2546 VIN.n220 VIN.n221 4.5005
R2547 VIN.n222 VIN.n223 4.5005
R2548 VIN.n224 VIN.n225 4.5005
R2549 VIN.n226 VIN.n227 4.5005
R2550 VIN.n228 VIN.n229 4.5005
R2551 VIN.n231 VIN.n230 4.5005
R2552 VIN.n232 VIN.n233 4.5005
R2553 VIN.n234 VIN.n235 4.5005
R2554 VIN.n237 VIN.n236 4.5005
R2555 VIN.n238 VIN.n239 4.5005
R2556 VIN.n240 VIN.n241 4.5005
R2557 VIN.n242 VIN.n243 4.5005
R2558 VIN.n244 VIN.n245 4.5005
R2559 VIN.n246 VIN.n247 4.5005
R2560 VIN.n249 VIN.n248 4.5005
R2561 VIN.n250 VIN.n251 4.5005
R2562 VIN.n253 VIN.n252 4.5005
R2563 VIN.n254 VIN.n255 4.5005
R2564 VIN.n257 VIN.n256 4.5005
R2565 VIN.n133 VIN.n135 0.1445
R2566 VIN.n135 VIN.n137 0.1445
R2567 VIN.n137 VIN.n139 0.1445
R2568 VIN.n139 VIN.n141 0.1445
R2569 VIN.n141 VIN.n143 0.1445
R2570 VIN.n143 VIN.n145 0.1445
R2571 VIN.n145 VIN.n147 0.1445
R2572 VIN.n147 VIN.n149 0.1445
R2573 VIN.n149 VIN.n151 0.1445
R2574 VIN.n151 VIN.n153 0.1445
R2575 VIN.n153 VIN.n155 0.1445
R2576 VIN.n155 VIN.n157 0.1445
R2577 VIN.n157 VIN.n159 0.1445
R2578 VIN.n159 VIN.n161 0.1445
R2579 VIN.n161 VIN.n163 0.1445
R2580 VIN.n163 VIN.n165 0.1445
R2581 VIN.n165 VIN.n167 0.1445
R2582 VIN.n167 VIN.n169 0.1445
R2583 VIN.n169 VIN.n171 0.1445
R2584 VIN.n171 VIN.n173 0.1445
R2585 VIN.n173 VIN.n175 0.1445
R2586 VIN.n175 VIN.n177 0.1445
R2587 VIN.n177 VIN.n179 0.1445
R2588 VIN.n179 VIN.n181 0.1445
R2589 VIN.n181 VIN.n183 0.1445
R2590 VIN.n183 VIN.n185 0.1445
R2591 VIN.n185 VIN.n187 0.1445
R2592 VIN.n187 VIN.n189 0.1445
R2593 VIN.n189 VIN.n191 0.1445
R2594 VIN.n191 VIN.n193 0.1445
R2595 VIN.n193 VIN.n195 0.1445
R2596 VIN.n195 VIN.n197 0.1445
R2597 VIN.n197 VIN.n199 0.1445
R2598 VIN.n199 VIN.n201 0.1445
R2599 VIN.n201 VIN.n203 0.1445
R2600 VIN.n203 VIN.n205 0.1445
R2601 VIN.n207 VIN.n205 0.1445
R2602 VIN.n209 VIN.n207 0.1445
R2603 VIN.n211 VIN.n209 0.1445
R2604 VIN.n213 VIN.n211 0.1445
R2605 VIN.n215 VIN.n213 0.1445
R2606 VIN.n217 VIN.n215 0.1445
R2607 VIN.n219 VIN.n217 0.1445
R2608 VIN.n221 VIN.n219 0.1445
R2609 VIN.n223 VIN.n221 0.1445
R2610 VIN.n225 VIN.n223 0.1445
R2611 VIN.n227 VIN.n225 0.1445
R2612 VIN.n229 VIN.n227 0.1445
R2613 VIN.n231 VIN.n229 0.1445
R2614 VIN.n233 VIN.n231 0.1445
R2615 VIN.n235 VIN.n233 0.1445
R2616 VIN.n237 VIN.n235 0.1445
R2617 VIN.n239 VIN.n237 0.1445
R2618 VIN.n241 VIN.n239 0.1445
R2619 VIN.n243 VIN.n241 0.1445
R2620 VIN.n245 VIN.n243 0.1445
R2621 VIN.n247 VIN.n245 0.1445
R2622 VIN.n249 VIN.n247 0.1445
R2623 VIN.n251 VIN.n249 0.1445
R2624 VIN.n253 VIN.n251 0.1445
R2625 VIN.n255 VIN.n253 0.1445
R2626 VIN.n257 VIN.n255 0.1445
R2627 VIN.n132 VIN.n257 0.1445
R2628 VIN.n579 VIN.n133 5.7099
R2629 VIN.n579 VIN.n581 2.13702
R2630 VIN.n581 VIN.n580 0.348761
R2631 VIN.n580 VIN.t248 2.72428
R2632 VIN.n581 VIN.t249 2.37602
R2633 VIN.n580 VIN.t247 18.1872
R2634 VIN.n258 VIN.n579 0.266409
R2635 VIN.n576 VIN.n258 0.266409
R2636 VIN.n576 VIN.n578 2.13702
R2637 VIN.n578 VIN.n577 0.348761
R2638 VIN.n578 VIN.t237 2.37602
R2639 VIN.n577 VIN.t238 2.72428
R2640 VIN.n577 VIN.t235 18.1872
R2641 VIN.n266 VIN.n265 0.0974231
R2642 VIN.n266 VIN.n576 1.47767
R2643 VIN.n268 VIN.n266 7.9149
R2644 VIN.n268 VIN.n267 4.5005
R2645 VIN.n269 VIN.n270 4.5005
R2646 VIN.n271 VIN.n272 4.5005
R2647 VIN.n273 VIN.n274 4.5005
R2648 VIN.n275 VIN.n276 4.5005
R2649 VIN.n278 VIN.n277 4.5005
R2650 VIN.n279 VIN.n280 4.5005
R2651 VIN.n281 VIN.n282 4.5005
R2652 VIN.n283 VIN.n284 4.5005
R2653 VIN.n285 VIN.n286 4.5005
R2654 VIN.n287 VIN.n288 4.5005
R2655 VIN.n290 VIN.n289 4.5005
R2656 VIN.n270 VIN.n268 0.1445
R2657 VIN.n272 VIN.n270 0.1445
R2658 VIN.n274 VIN.n272 0.1445
R2659 VIN.n276 VIN.n274 0.1445
R2660 VIN.n278 VIN.n276 0.1445
R2661 VIN.n280 VIN.n278 0.1445
R2662 VIN.n282 VIN.n280 0.1445
R2663 VIN.n284 VIN.n282 0.1445
R2664 VIN.n286 VIN.n284 0.1445
R2665 VIN.n288 VIN.n286 0.1445
R2666 VIN.n290 VIN.n288 0.1445
R2667 VIN.n292 VIN.n291 4.5005
R2668 VIN.n292 VIN.n290 0.1213
R2669 VIN.n293 VIN.n292 0.0165
R2670 VIN.n298 VIN.n297 4.5005
R2671 VIN.n299 VIN.n300 4.5005
R2672 VIN.n301 VIN.n302 4.5005
R2673 VIN.n304 VIN.n303 4.5005
R2674 VIN.n306 VIN.n305 4.5005
R2675 VIN.n307 VIN.n308 4.5005
R2676 VIN.n309 VIN.n310 4.5005
R2677 VIN.n311 VIN.n312 4.5005
R2678 VIN.n313 VIN.n314 4.5005
R2679 VIN.n315 VIN.n316 4.5005
R2680 VIN.n318 VIN.n317 4.5005
R2681 VIN.n319 VIN.n320 4.5005
R2682 VIN.n321 VIN.n322 4.5005
R2683 VIN.n324 VIN.n323 4.5005
R2684 VIN.n326 VIN.n325 4.5005
R2685 VIN.n293 VIN.n298 0.0797
R2686 VIN.n298 VIN.n300 0.1445
R2687 VIN.n300 VIN.n302 0.1445
R2688 VIN.n302 VIN.n304 0.1445
R2689 VIN.n304 VIN.n306 0.1445
R2690 VIN.n306 VIN.n308 0.1445
R2691 VIN.n308 VIN.n310 0.1445
R2692 VIN.n310 VIN.n312 0.1445
R2693 VIN.n312 VIN.n314 0.1445
R2694 VIN.n316 VIN.n314 0.1445
R2695 VIN.n318 VIN.n316 0.1445
R2696 VIN.n320 VIN.n318 0.1445
R2697 VIN.n322 VIN.n320 0.1445
R2698 VIN.n324 VIN.n322 0.1445
R2699 VIN.n326 VIN.n324 0.1445
R2700 VIN.n332 VIN.n331 4.5005
R2701 VIN.n332 VIN.n326 0.1213
R2702 VIN.n327 VIN.n332 0.0165
R2703 VIN.n334 VIN.n333 4.5005
R2704 VIN.n335 VIN.n336 4.5005
R2705 VIN.n338 VIN.n337 4.5005
R2706 VIN.n340 VIN.n339 4.5005
R2707 VIN.n342 VIN.n341 4.5005
R2708 VIN.n344 VIN.n343 4.5005
R2709 VIN.n345 VIN.n346 4.5005
R2710 VIN.n348 VIN.n347 4.5005
R2711 VIN.n349 VIN.n350 4.5005
R2712 VIN.n352 VIN.n351 4.5005
R2713 VIN.n353 VIN.n354 4.5005
R2714 VIN.n356 VIN.n355 4.5005
R2715 VIN.n357 VIN.n358 4.5005
R2716 VIN.n360 VIN.n359 4.5005
R2717 VIN.n575 VIN.n361 4.5005
R2718 VIN.n327 VIN.n334 0.0797
R2719 VIN.n334 VIN.n336 0.1445
R2720 VIN.n336 VIN.n338 0.1445
R2721 VIN.n338 VIN.n340 0.1445
R2722 VIN.n340 VIN.n342 0.1445
R2723 VIN.n342 VIN.n344 0.1445
R2724 VIN.n344 VIN.n346 0.1445
R2725 VIN.n346 VIN.n348 0.1445
R2726 VIN.n348 VIN.n350 0.1445
R2727 VIN.n352 VIN.n350 0.1445
R2728 VIN.n354 VIN.n352 0.1445
R2729 VIN.n356 VIN.n354 0.1445
R2730 VIN.n358 VIN.n356 0.1445
R2731 VIN.n360 VIN.n358 0.1445
R2732 VIN.n575 VIN.n360 0.1445
R2733 VIN.n89 VIN.n575 0.1213
R2734 VIN.n363 VIN.n362 6.3005
R2735 VIN.n90 VIN.n363 6.3005
R2736 VIN.n365 VIN.n364 6.3005
R2737 VIN.n126 VIN.n365 6.3005
R2738 VIN.n367 VIN.n366 6.3005
R2739 VIN.n124 VIN.n367 6.3005
R2740 VIN.n369 VIN.n368 6.3005
R2741 VIN.n122 VIN.n369 6.3005
R2742 VIN.n371 VIN.n370 6.3005
R2743 VIN.n120 VIN.n371 6.3005
R2744 VIN.n373 VIN.n372 6.3005
R2745 VIN.n118 VIN.n373 6.3005
R2746 VIN.n375 VIN.n374 6.3005
R2747 VIN.n116 VIN.n375 6.3005
R2748 VIN.n377 VIN.n376 6.3005
R2749 VIN.n114 VIN.n377 6.3005
R2750 VIN.n379 VIN.n378 6.3005
R2751 VIN.n112 VIN.n379 6.3005
R2752 VIN.n381 VIN.n380 6.3005
R2753 VIN.n110 VIN.n381 6.3005
R2754 VIN.n383 VIN.n382 6.3005
R2755 VIN.n108 VIN.n383 6.3005
R2756 VIN.n385 VIN.n384 6.3005
R2757 VIN.n106 VIN.n385 6.3005
R2758 VIN.n387 VIN.n386 6.3005
R2759 VIN.n104 VIN.n387 6.3005
R2760 VIN.n389 VIN.n388 6.3005
R2761 VIN.n102 VIN.n389 6.3005
R2762 VIN.n390 VIN.t262 6.3005
R2763 VIN.n100 VIN.n390 6.3005
R2764 VIN.n392 VIN.n391 6.3005
R2765 VIN.n98 VIN.n392 6.3005
R2766 VIN.n394 VIN.n393 6.3005
R2767 VIN.n96 VIN.n394 6.3005
R2768 VIN.n396 VIN.n395 6.3005
R2769 VIN.n94 VIN.n396 6.3005
R2770 VIN.n398 VIN.n397 6.3005
R2771 VIN.n92 VIN.n398 6.3005
R2772 VIN.n400 VIN.n399 6.3005
R2773 VIN.n88 VIN.n400 6.3005
R2774 VIN.n402 VIN.n401 6.3005
R2775 VIN.n361 VIN.n402 6.3005
R2776 VIN.n404 VIN.n403 6.3005
R2777 VIN.n359 VIN.n404 6.3005
R2778 VIN.n406 VIN.n405 6.3005
R2779 VIN.n357 VIN.n406 6.3005
R2780 VIN.n408 VIN.n407 6.3005
R2781 VIN.n355 VIN.n408 6.3005
R2782 VIN.n410 VIN.n409 6.3005
R2783 VIN.n353 VIN.n410 6.3005
R2784 VIN.n412 VIN.n411 6.3005
R2785 VIN.n351 VIN.n412 6.3005
R2786 VIN.n414 VIN.n413 6.3005
R2787 VIN.n349 VIN.n414 6.3005
R2788 VIN.n416 VIN.n415 6.3005
R2789 VIN.n347 VIN.n416 6.3005
R2790 VIN.n418 VIN.n417 6.3005
R2791 VIN.n345 VIN.n418 6.3005
R2792 VIN.n420 VIN.n419 6.3005
R2793 VIN.n343 VIN.n420 6.3005
R2794 VIN.n422 VIN.n421 6.3005
R2795 VIN.n341 VIN.n422 6.3005
R2796 VIN.n424 VIN.n423 6.3005
R2797 VIN.n339 VIN.n424 6.3005
R2798 VIN.n426 VIN.n425 6.3005
R2799 VIN.n337 VIN.n426 6.3005
R2800 VIN.n428 VIN.n427 6.3005
R2801 VIN.n335 VIN.n428 6.3005
R2802 VIN.n430 VIN.n429 6.3005
R2803 VIN.n333 VIN.n430 6.3005
R2804 VIN.n432 VIN.n431 6.3005
R2805 VIN.n331 VIN.n432 6.3005
R2806 VIN.n434 VIN.n433 6.3005
R2807 VIN.n325 VIN.n434 6.3005
R2808 VIN.n436 VIN.n435 6.3005
R2809 VIN.n323 VIN.n436 6.3005
R2810 VIN.n438 VIN.n437 6.3005
R2811 VIN.n321 VIN.n438 6.3005
R2812 VIN.n440 VIN.n439 6.3005
R2813 VIN.n319 VIN.n440 6.3005
R2814 VIN.n442 VIN.n441 6.3005
R2815 VIN.n317 VIN.n442 6.3005
R2816 VIN.n444 VIN.n443 6.3005
R2817 VIN.n315 VIN.n444 6.3005
R2818 VIN.n446 VIN.n445 6.3005
R2819 VIN.n313 VIN.n446 6.3005
R2820 VIN.n448 VIN.n447 6.3005
R2821 VIN.n311 VIN.n448 6.3005
R2822 VIN.n450 VIN.n449 6.3005
R2823 VIN.n309 VIN.n450 6.3005
R2824 VIN.n452 VIN.n451 6.3005
R2825 VIN.n307 VIN.n452 6.3005
R2826 VIN.n454 VIN.n453 6.3005
R2827 VIN.n305 VIN.n454 6.3005
R2828 VIN.n456 VIN.n455 6.3005
R2829 VIN.n303 VIN.n456 6.3005
R2830 VIN.n458 VIN.n457 6.3005
R2831 VIN.n301 VIN.n458 6.3005
R2832 VIN.n460 VIN.n459 6.3005
R2833 VIN.n299 VIN.n460 6.3005
R2834 VIN.n462 VIN.n461 6.3005
R2835 VIN.n297 VIN.n462 6.3005
R2836 VIN.n464 VIN.n463 6.3005
R2837 VIN.n291 VIN.n464 6.3005
R2838 VIN.n466 VIN.n465 6.3005
R2839 VIN.n289 VIN.n466 6.3005
R2840 VIN.n468 VIN.n467 6.3005
R2841 VIN.n287 VIN.n468 6.3005
R2842 VIN.n470 VIN.n469 6.3005
R2843 VIN.n285 VIN.n470 6.3005
R2844 VIN.n472 VIN.n471 6.3005
R2845 VIN.n283 VIN.n472 6.3005
R2846 VIN.n474 VIN.n473 6.3005
R2847 VIN.n281 VIN.n474 6.3005
R2848 VIN.n476 VIN.n475 6.3005
R2849 VIN.n279 VIN.n476 6.3005
R2850 VIN.n478 VIN.n477 6.3005
R2851 VIN.n277 VIN.n478 6.3005
R2852 VIN.n480 VIN.n479 6.3005
R2853 VIN.n275 VIN.n480 6.3005
R2854 VIN.n482 VIN.n481 6.3005
R2855 VIN.n273 VIN.n482 6.3005
R2856 VIN.n484 VIN.n483 6.3005
R2857 VIN.n271 VIN.n484 6.3005
R2858 VIN.n486 VIN.n485 6.3005
R2859 VIN.n269 VIN.n486 6.3005
R2860 VIN.n574 VIN.n567 6.3005
R2861 VIN.n267 VIN.n574 6.3005
R2862 VIN.n267 VIN.n269 0.1445
R2863 VIN.n271 VIN.n269 0.1445
R2864 VIN.n273 VIN.n271 0.1445
R2865 VIN.n275 VIN.n273 0.1445
R2866 VIN.n277 VIN.n275 0.1445
R2867 VIN.n277 VIN.n279 0.1445
R2868 VIN.n281 VIN.n279 0.1445
R2869 VIN.n283 VIN.n281 0.1445
R2870 VIN.n285 VIN.n283 0.1445
R2871 VIN.n287 VIN.n285 0.1445
R2872 VIN.n289 VIN.n287 0.1445
R2873 VIN.n289 VIN.n291 0.1445
R2874 VIN.n291 VIN.n297 0.1445
R2875 VIN.n297 VIN.n299 0.1445
R2876 VIN.n299 VIN.n301 0.1445
R2877 VIN.n301 VIN.n303 0.1445
R2878 VIN.n303 VIN.n305 0.1445
R2879 VIN.n305 VIN.n307 0.1445
R2880 VIN.n307 VIN.n309 0.1445
R2881 VIN.n309 VIN.n311 0.1445
R2882 VIN.n311 VIN.n313 0.1445
R2883 VIN.n315 VIN.n313 0.1445
R2884 VIN.n317 VIN.n315 0.1445
R2885 VIN.n317 VIN.n319 0.1445
R2886 VIN.n321 VIN.n319 0.1445
R2887 VIN.n323 VIN.n321 0.1445
R2888 VIN.n323 VIN.n325 0.1445
R2889 VIN.n325 VIN.n331 0.1445
R2890 VIN.n331 VIN.n333 0.1445
R2891 VIN.n333 VIN.n335 0.1445
R2892 VIN.n335 VIN.n337 0.1445
R2893 VIN.n337 VIN.n339 0.1445
R2894 VIN.n339 VIN.n341 0.1445
R2895 VIN.n341 VIN.n343 0.1445
R2896 VIN.n343 VIN.n345 0.1445
R2897 VIN.n345 VIN.n347 0.1445
R2898 VIN.n347 VIN.n349 0.1445
R2899 VIN.n351 VIN.n349 0.1445
R2900 VIN.n351 VIN.n353 0.1445
R2901 VIN.n355 VIN.n353 0.1445
R2902 VIN.n355 VIN.n357 0.1445
R2903 VIN.n359 VIN.n357 0.1445
R2904 VIN.n359 VIN.n361 0.1445
R2905 VIN.n361 VIN.n88 0.1445
R2906 VIN.n88 VIN.n92 0.1445
R2907 VIN.n92 VIN.n94 0.1445
R2908 VIN.n94 VIN.n96 0.1445
R2909 VIN.n96 VIN.n98 0.1445
R2910 VIN.n98 VIN.n100 0.1445
R2911 VIN.n100 VIN.n102 0.1445
R2912 VIN.n102 VIN.n104 0.1445
R2913 VIN.n104 VIN.n106 0.1445
R2914 VIN.n106 VIN.n108 0.1445
R2915 VIN.n108 VIN.n110 0.1445
R2916 VIN.n110 VIN.n112 0.1445
R2917 VIN.n112 VIN.n114 0.1445
R2918 VIN.n114 VIN.n116 0.1445
R2919 VIN.n116 VIN.n118 0.1445
R2920 VIN.n118 VIN.n120 0.1445
R2921 VIN.n120 VIN.n122 0.1445
R2922 VIN.n122 VIN.n124 0.1445
R2923 VIN.n124 VIN.n126 0.1445
R2924 VIN.n126 VIN.n90 0.1445
R2925 VIN.n574 VIN.n486 14.0005
R2926 VIN.n486 VIN.n484 14.0005
R2927 VIN.n484 VIN.n482 14.0005
R2928 VIN.n482 VIN.n480 14.0005
R2929 VIN.n480 VIN.n478 14.0005
R2930 VIN.n478 VIN.n476 14.0005
R2931 VIN.n476 VIN.n474 14.0005
R2932 VIN.n474 VIN.n472 14.0005
R2933 VIN.n472 VIN.n470 14.0005
R2934 VIN.n470 VIN.n468 14.0005
R2935 VIN.n468 VIN.n466 14.0005
R2936 VIN.n466 VIN.n464 14.0005
R2937 VIN.n464 VIN.n462 14.0005
R2938 VIN.n462 VIN.n460 14.0005
R2939 VIN.n460 VIN.n458 14.0005
R2940 VIN.n458 VIN.n456 14.0005
R2941 VIN.n456 VIN.n454 14.0005
R2942 VIN.n454 VIN.n452 14.0005
R2943 VIN.n452 VIN.n450 14.0005
R2944 VIN.n450 VIN.n448 14.0005
R2945 VIN.n448 VIN.n446 14.0005
R2946 VIN.n446 VIN.n444 14.0005
R2947 VIN.n444 VIN.n442 14.0005
R2948 VIN.n442 VIN.n440 14.0005
R2949 VIN.n440 VIN.n438 14.0005
R2950 VIN.n438 VIN.n436 14.0005
R2951 VIN.n436 VIN.n434 14.0005
R2952 VIN.n434 VIN.n432 14.0005
R2953 VIN.n432 VIN.n430 14.0005
R2954 VIN.n430 VIN.n428 14.0005
R2955 VIN.n428 VIN.n426 14.0005
R2956 VIN.n426 VIN.n424 14.0005
R2957 VIN.n424 VIN.n422 14.0005
R2958 VIN.n422 VIN.n420 14.0005
R2959 VIN.n420 VIN.n418 14.0005
R2960 VIN.n418 VIN.n416 14.0005
R2961 VIN.n416 VIN.n414 14.0005
R2962 VIN.n414 VIN.n412 14.0005
R2963 VIN.n412 VIN.n410 14.0005
R2964 VIN.n410 VIN.n408 14.0005
R2965 VIN.n408 VIN.n406 14.0005
R2966 VIN.n406 VIN.n404 14.0005
R2967 VIN.n404 VIN.n402 14.0005
R2968 VIN.n402 VIN.n400 14.0005
R2969 VIN.n400 VIN.n398 14.0005
R2970 VIN.n398 VIN.n396 14.0005
R2971 VIN.n396 VIN.n394 14.0005
R2972 VIN.n394 VIN.n392 14.0005
R2973 VIN.n392 VIN.n390 14.0005
R2974 VIN.n390 VIN.n389 14.0005
R2975 VIN.n389 VIN.n387 14.0005
R2976 VIN.n387 VIN.n385 14.0005
R2977 VIN.n385 VIN.n383 14.0005
R2978 VIN.n383 VIN.n381 14.0005
R2979 VIN.n381 VIN.n379 14.0005
R2980 VIN.n379 VIN.n377 14.0005
R2981 VIN.n377 VIN.n375 14.0005
R2982 VIN.n375 VIN.n373 14.0005
R2983 VIN.n373 VIN.n371 14.0005
R2984 VIN.n371 VIN.n369 14.0005
R2985 VIN.n369 VIN.n367 14.0005
R2986 VIN.n367 VIN.n365 14.0005
R2987 VIN.n365 VIN.n363 14.0005
R2988 VIN.n363 VIN.n487 98.963
R2989 VIN.t116 VIN.n488 0.0720909
R2990 VIN.n488 VIN.n492 0.0720909
R2991 VIN.n573 VIN.n488 364.853
R2992 VIN.n488 VIN.n487 364.853
R2993 VIN.n265 VIN.n493 41.6505
R2994 VIN.n265 VIN.n573 197.925
R2995 VIN.n574 VIN.n573 98.963
R2996 VIN.t116 VIN.n494 0.0720909
R2997 VIN.n494 VIN.n503 0.0720909
R2998 VIN.n493 VIN.n494 364.853
R2999 VIN.n494 VIN.n572 364.853
R3000 VIN.n128 VIN.n572 41.6505
R3001 VIN.n128 VIN.n487 197.925
R3002 VIN.n362 VIN.n504 6.3005
R3003 VIN.n504 VIN.n131 6.3005
R3004 VIN.n364 VIN.n505 6.3005
R3005 VIN.n505 VIN.n256 6.3005
R3006 VIN.n366 VIN.n506 6.3005
R3007 VIN.n506 VIN.n254 6.3005
R3008 VIN.n368 VIN.n507 6.3005
R3009 VIN.n507 VIN.n252 6.3005
R3010 VIN.n370 VIN.n508 6.3005
R3011 VIN.n508 VIN.n250 6.3005
R3012 VIN.n372 VIN.n509 6.3005
R3013 VIN.n509 VIN.n248 6.3005
R3014 VIN.n374 VIN.n510 6.3005
R3015 VIN.n510 VIN.n246 6.3005
R3016 VIN.n376 VIN.n511 6.3005
R3017 VIN.n511 VIN.n244 6.3005
R3018 VIN.n378 VIN.n512 6.3005
R3019 VIN.n512 VIN.n242 6.3005
R3020 VIN.n380 VIN.n513 6.3005
R3021 VIN.n513 VIN.n240 6.3005
R3022 VIN.n382 VIN.n514 6.3005
R3023 VIN.n514 VIN.n238 6.3005
R3024 VIN.n384 VIN.n515 6.3005
R3025 VIN.n515 VIN.n236 6.3005
R3026 VIN.n386 VIN.n516 6.3005
R3027 VIN.n516 VIN.n234 6.3005
R3028 VIN.n388 VIN.n517 6.3005
R3029 VIN.n517 VIN.n232 6.3005
R3030 VIN.t262 VIN.n518 6.3005
R3031 VIN.n518 VIN.n230 6.3005
R3032 VIN.n391 VIN.n519 6.3005
R3033 VIN.n519 VIN.n228 6.3005
R3034 VIN.n393 VIN.n520 6.3005
R3035 VIN.n520 VIN.n226 6.3005
R3036 VIN.n395 VIN.n521 6.3005
R3037 VIN.n521 VIN.n224 6.3005
R3038 VIN.n397 VIN.n522 6.3005
R3039 VIN.n522 VIN.n222 6.3005
R3040 VIN.n399 VIN.n523 6.3005
R3041 VIN.n523 VIN.n220 6.3005
R3042 VIN.n401 VIN.n524 6.3005
R3043 VIN.n524 VIN.n218 6.3005
R3044 VIN.n403 VIN.n525 6.3005
R3045 VIN.n525 VIN.n216 6.3005
R3046 VIN.n405 VIN.n526 6.3005
R3047 VIN.n526 VIN.n214 6.3005
R3048 VIN.n407 VIN.n527 6.3005
R3049 VIN.n527 VIN.n212 6.3005
R3050 VIN.n409 VIN.n528 6.3005
R3051 VIN.n528 VIN.n210 6.3005
R3052 VIN.n411 VIN.n529 6.3005
R3053 VIN.n529 VIN.n208 6.3005
R3054 VIN.n413 VIN.n530 6.3005
R3055 VIN.n530 VIN.n206 6.3005
R3056 VIN.n415 VIN.n531 6.3005
R3057 VIN.n531 VIN.n204 6.3005
R3058 VIN.n417 VIN.n532 6.3005
R3059 VIN.n532 VIN.n202 6.3005
R3060 VIN.n419 VIN.n533 6.3005
R3061 VIN.n533 VIN.n200 6.3005
R3062 VIN.n421 VIN.n534 6.3005
R3063 VIN.n534 VIN.n198 6.3005
R3064 VIN.n423 VIN.n535 6.3005
R3065 VIN.n535 VIN.n196 6.3005
R3066 VIN.n425 VIN.n536 6.3005
R3067 VIN.n536 VIN.n194 6.3005
R3068 VIN.n427 VIN.n537 6.3005
R3069 VIN.n537 VIN.n192 6.3005
R3070 VIN.n429 VIN.n538 6.3005
R3071 VIN.n538 VIN.n190 6.3005
R3072 VIN.n431 VIN.n539 6.3005
R3073 VIN.n539 VIN.n188 6.3005
R3074 VIN.n433 VIN.n540 6.3005
R3075 VIN.n540 VIN.n186 6.3005
R3076 VIN.n435 VIN.n541 6.3005
R3077 VIN.n541 VIN.n184 6.3005
R3078 VIN.n437 VIN.n542 6.3005
R3079 VIN.n542 VIN.n182 6.3005
R3080 VIN.n439 VIN.n543 6.3005
R3081 VIN.n543 VIN.n180 6.3005
R3082 VIN.n441 VIN.n544 6.3005
R3083 VIN.n544 VIN.n178 6.3005
R3084 VIN.n443 VIN.n545 6.3005
R3085 VIN.n545 VIN.n176 6.3005
R3086 VIN.n445 VIN.n546 6.3005
R3087 VIN.n546 VIN.n174 6.3005
R3088 VIN.n447 VIN.n547 6.3005
R3089 VIN.n547 VIN.n172 6.3005
R3090 VIN.n449 VIN.n548 6.3005
R3091 VIN.n548 VIN.n170 6.3005
R3092 VIN.n451 VIN.n549 6.3005
R3093 VIN.n549 VIN.n168 6.3005
R3094 VIN.n453 VIN.n550 6.3005
R3095 VIN.n550 VIN.n166 6.3005
R3096 VIN.n455 VIN.n551 6.3005
R3097 VIN.n551 VIN.n164 6.3005
R3098 VIN.n457 VIN.n552 6.3005
R3099 VIN.n552 VIN.n162 6.3005
R3100 VIN.n459 VIN.n553 6.3005
R3101 VIN.n553 VIN.n160 6.3005
R3102 VIN.n461 VIN.n554 6.3005
R3103 VIN.n554 VIN.n158 6.3005
R3104 VIN.n463 VIN.n555 6.3005
R3105 VIN.n555 VIN.n156 6.3005
R3106 VIN.n465 VIN.n556 6.3005
R3107 VIN.n556 VIN.n154 6.3005
R3108 VIN.n467 VIN.n557 6.3005
R3109 VIN.n557 VIN.n152 6.3005
R3110 VIN.n469 VIN.n558 6.3005
R3111 VIN.n558 VIN.n150 6.3005
R3112 VIN.n471 VIN.n559 6.3005
R3113 VIN.n559 VIN.n148 6.3005
R3114 VIN.n473 VIN.n560 6.3005
R3115 VIN.n560 VIN.n146 6.3005
R3116 VIN.n475 VIN.n561 6.3005
R3117 VIN.n561 VIN.n144 6.3005
R3118 VIN.n477 VIN.n562 6.3005
R3119 VIN.n562 VIN.n142 6.3005
R3120 VIN.n479 VIN.n563 6.3005
R3121 VIN.n563 VIN.n140 6.3005
R3122 VIN.n481 VIN.n564 6.3005
R3123 VIN.n564 VIN.n138 6.3005
R3124 VIN.n483 VIN.n565 6.3005
R3125 VIN.n565 VIN.n136 6.3005
R3126 VIN.n485 VIN.n566 6.3005
R3127 VIN.n566 VIN.n134 6.3005
R3128 VIN.n567 VIN.n568 6.3005
R3129 VIN.n568 VIN.n569 6.3005
R3130 VIN.n568 VIN.n566 14.0005
R3131 VIN.n566 VIN.n565 14.0005
R3132 VIN.n565 VIN.n564 14.0005
R3133 VIN.n564 VIN.n563 14.0005
R3134 VIN.n563 VIN.n562 14.0005
R3135 VIN.n562 VIN.n561 14.0005
R3136 VIN.n561 VIN.n560 14.0005
R3137 VIN.n560 VIN.n559 14.0005
R3138 VIN.n559 VIN.n558 14.0005
R3139 VIN.n558 VIN.n557 14.0005
R3140 VIN.n557 VIN.n556 14.0005
R3141 VIN.n556 VIN.n555 14.0005
R3142 VIN.n555 VIN.n554 14.0005
R3143 VIN.n554 VIN.n553 14.0005
R3144 VIN.n553 VIN.n552 14.0005
R3145 VIN.n552 VIN.n551 14.0005
R3146 VIN.n551 VIN.n550 14.0005
R3147 VIN.n550 VIN.n549 14.0005
R3148 VIN.n549 VIN.n548 14.0005
R3149 VIN.n548 VIN.n547 14.0005
R3150 VIN.n547 VIN.n546 14.0005
R3151 VIN.n546 VIN.n545 14.0005
R3152 VIN.n545 VIN.n544 14.0005
R3153 VIN.n544 VIN.n543 14.0005
R3154 VIN.n543 VIN.n542 14.0005
R3155 VIN.n542 VIN.n541 14.0005
R3156 VIN.n541 VIN.n540 14.0005
R3157 VIN.n540 VIN.n539 14.0005
R3158 VIN.n539 VIN.n538 14.0005
R3159 VIN.n538 VIN.n537 14.0005
R3160 VIN.n537 VIN.n536 14.0005
R3161 VIN.n536 VIN.n535 14.0005
R3162 VIN.n535 VIN.n534 14.0005
R3163 VIN.n534 VIN.n533 14.0005
R3164 VIN.n533 VIN.n532 14.0005
R3165 VIN.n532 VIN.n531 14.0005
R3166 VIN.n531 VIN.n530 14.0005
R3167 VIN.n530 VIN.n529 14.0005
R3168 VIN.n529 VIN.n528 14.0005
R3169 VIN.n528 VIN.n527 14.0005
R3170 VIN.n527 VIN.n526 14.0005
R3171 VIN.n526 VIN.n525 14.0005
R3172 VIN.n525 VIN.n524 14.0005
R3173 VIN.n524 VIN.n523 14.0005
R3174 VIN.n523 VIN.n522 14.0005
R3175 VIN.n522 VIN.n521 14.0005
R3176 VIN.n521 VIN.n520 14.0005
R3177 VIN.n520 VIN.n519 14.0005
R3178 VIN.n519 VIN.n518 14.0005
R3179 VIN.n518 VIN.n517 14.0005
R3180 VIN.n517 VIN.n516 14.0005
R3181 VIN.n516 VIN.n515 14.0005
R3182 VIN.n515 VIN.n514 14.0005
R3183 VIN.n514 VIN.n513 14.0005
R3184 VIN.n513 VIN.n512 14.0005
R3185 VIN.n512 VIN.n511 14.0005
R3186 VIN.n511 VIN.n510 14.0005
R3187 VIN.n510 VIN.n509 14.0005
R3188 VIN.n509 VIN.n508 14.0005
R3189 VIN.n508 VIN.n507 14.0005
R3190 VIN.n507 VIN.n506 14.0005
R3191 VIN.n506 VIN.n505 14.0005
R3192 VIN.n505 VIN.n504 14.0005
R3193 VIN.n504 VIN.n572 255.238
R3194 VIN.n568 VIN.n493 255.238
R3195 VIN.n569 VIN.n134 0.1445
R3196 VIN.n134 VIN.n136 0.1445
R3197 VIN.n136 VIN.n138 0.1445
R3198 VIN.n138 VIN.n140 0.1445
R3199 VIN.n140 VIN.n142 0.1445
R3200 VIN.n142 VIN.n144 0.1445
R3201 VIN.n144 VIN.n146 0.1445
R3202 VIN.n146 VIN.n148 0.1445
R3203 VIN.n148 VIN.n150 0.1445
R3204 VIN.n150 VIN.n152 0.1445
R3205 VIN.n152 VIN.n154 0.1445
R3206 VIN.n154 VIN.n156 0.1445
R3207 VIN.n156 VIN.n158 0.1445
R3208 VIN.n158 VIN.n160 0.1445
R3209 VIN.n160 VIN.n162 0.1445
R3210 VIN.n162 VIN.n164 0.1445
R3211 VIN.n164 VIN.n166 0.1445
R3212 VIN.n166 VIN.n168 0.1445
R3213 VIN.n168 VIN.n170 0.1445
R3214 VIN.n170 VIN.n172 0.1445
R3215 VIN.n172 VIN.n571 0.0545
R3216 VIN.n571 VIN.n174 0.0905
R3217 VIN.n174 VIN.n176 0.1445
R3218 VIN.n176 VIN.n178 0.1445
R3219 VIN.n178 VIN.n180 0.1445
R3220 VIN.n180 VIN.n182 0.1445
R3221 VIN.n182 VIN.n184 0.1445
R3222 VIN.n184 VIN.n186 0.1445
R3223 VIN.n186 VIN.n188 0.1445
R3224 VIN.n188 VIN.n190 0.1445
R3225 VIN.n190 VIN.n192 0.1445
R3226 VIN.n192 VIN.n194 0.1445
R3227 VIN.n194 VIN.n196 0.1445
R3228 VIN.n196 VIN.n198 0.1445
R3229 VIN.n198 VIN.n200 0.1445
R3230 VIN.n200 VIN.n202 0.1445
R3231 VIN.n202 VIN.n204 0.1445
R3232 VIN.n204 VIN.n206 0.1445
R3233 VIN.n206 VIN.n208 0.1445
R3234 VIN.n208 VIN.n210 0.1445
R3235 VIN.n210 VIN.n212 0.1445
R3236 VIN.n212 VIN.n214 0.1445
R3237 VIN.n214 VIN.n216 0.1445
R3238 VIN.n216 VIN.n570 0.0905
R3239 VIN.n218 VIN.n570 0.0545
R3240 VIN.n220 VIN.n218 0.1445
R3241 VIN.n222 VIN.n220 0.1445
R3242 VIN.n224 VIN.n222 0.1445
R3243 VIN.n226 VIN.n224 0.1445
R3244 VIN.n228 VIN.n226 0.1445
R3245 VIN.n230 VIN.n228 0.1445
R3246 VIN.n230 VIN.n232 0.1445
R3247 VIN.n234 VIN.n232 0.1445
R3248 VIN.n236 VIN.n234 0.1445
R3249 VIN.n236 VIN.n238 0.1445
R3250 VIN.n240 VIN.n238 0.1445
R3251 VIN.n242 VIN.n240 0.1445
R3252 VIN.n244 VIN.n242 0.1445
R3253 VIN.n246 VIN.n244 0.1445
R3254 VIN.n248 VIN.n246 0.1445
R3255 VIN.n248 VIN.n250 0.1445
R3256 VIN.n252 VIN.n250 0.1445
R3257 VIN.n252 VIN.n254 0.1445
R3258 VIN.n256 VIN.n254 0.1445
R3259 VIN.n256 VIN.n131 0.1445
R3260 VIN.n571 VIN.t250 14.3015
R3261 VIN.n570 VIN.t251 14.3015
R3262 VIN.n265 VIN.n567 41.5482
R3263 VIN.n567 VIN.n485 23.0287
R3264 VIN.n485 VIN.n483 23.0287
R3265 VIN.n483 VIN.n481 23.0287
R3266 VIN.n481 VIN.n479 23.0287
R3267 VIN.n479 VIN.n477 23.0287
R3268 VIN.n477 VIN.n475 23.0287
R3269 VIN.n475 VIN.n473 23.0287
R3270 VIN.n473 VIN.n471 23.0287
R3271 VIN.n471 VIN.n469 23.0287
R3272 VIN.n469 VIN.n467 23.0287
R3273 VIN.n467 VIN.n465 23.0287
R3274 VIN.n465 VIN.n463 23.0287
R3275 VIN.n463 VIN.n461 23.0287
R3276 VIN.n461 VIN.n459 23.0287
R3277 VIN.n459 VIN.t236 1.72762
R3278 VIN.t236 VIN.n457 21.3016
R3279 VIN.n457 VIN.n455 23.0287
R3280 VIN.n455 VIN.n453 23.0287
R3281 VIN.n453 VIN.n451 23.0287
R3282 VIN.n451 VIN.n449 23.0287
R3283 VIN.n449 VIN.n447 23.0287
R3284 VIN.n447 VIN.t240 8.63608
R3285 VIN.t240 VIN.t220 5.90148
R3286 VIN.n445 VIN.t220 8.49215
R3287 VIN.n445 VIN.n443 23.0287
R3288 VIN.n443 VIN.n441 23.0287
R3289 VIN.n441 VIN.t224 20.0063
R3290 VIN.n439 VIN.t224 3.02295
R3291 VIN.n439 VIN.t34 18.9988
R3292 VIN.n437 VIN.t34 4.03044
R3293 VIN.n437 VIN.t81 5.90148
R3294 VIN.t81 VIN.n435 17.1277
R3295 VIN.n435 VIN.t14 14.8249
R3296 VIN.n433 VIN.t14 8.2043
R3297 VIN.n433 VIN.n431 23.0287
R3298 VIN.n431 VIN.t226 0.720132
R3299 VIN.t226 VIN.n429 22.3091
R3300 VIN.n429 VIN.t65 6.33326
R3301 VIN.t65 VIN.t333 3.31081
R3302 VIN.t333 VIN.n427 13.3856
R3303 VIN.n427 VIN.t113 18.567
R3304 VIN.n425 VIN.t113 4.46222
R3305 VIN.n425 VIN.t116 11.5146
R3306 VIN.t116 VIN.n423 11.5146
R3307 VIN.n423 VIN.t50 4.46222
R3308 VIN.t50 VIN.n421 18.567
R3309 VIN.n421 VIN.t97 13.3856
R3310 VIN.t79 VIN.t97 3.31081
R3311 VIN.n419 VIN.t79 6.33326
R3312 VIN.n419 VIN.t228 22.3091
R3313 VIN.n417 VIN.t228 0.720132
R3314 VIN.n417 VIN.n415 23.0287
R3315 VIN.n415 VIN.t258 8.2043
R3316 VIN.t258 VIN.n413 14.8249
R3317 VIN.n413 VIN.t104 17.1277
R3318 VIN.n411 VIN.t104 5.90148
R3319 VIN.n411 VIN.t22 4.03044
R3320 VIN.t22 VIN.n409 18.9988
R3321 VIN.n409 VIN.t230 3.02295
R3322 VIN.t230 VIN.n407 20.0063
R3323 VIN.n407 VIN.n405 23.0287
R3324 VIN.n405 VIN.n403 23.0287
R3325 VIN.n403 VIN.t232 8.49215
R3326 VIN.t232 VIN.t242 5.90148
R3327 VIN.n401 VIN.t242 8.63608
R3328 VIN.n401 VIN.n399 23.0287
R3329 VIN.n399 VIN.n397 23.0287
R3330 VIN.n397 VIN.n395 23.0287
R3331 VIN.n395 VIN.n393 23.0287
R3332 VIN.n393 VIN.t260 12.666
R3333 VIN.n391 VIN.t260 10.3632
R3334 VIN.n391 VIN.t244 21.3016
R3335 VIN.t262 VIN.t244 1.72762
R3336 VIN.t262 VIN.n388 23.0287
R3337 VIN.n388 VIN.n386 23.0287
R3338 VIN.n386 VIN.n384 23.0287
R3339 VIN.n384 VIN.t264 12.9539
R3340 VIN.n382 VIN.t264 10.0753
R3341 VIN.n382 VIN.n380 23.0287
R3342 VIN.n380 VIN.n378 23.0287
R3343 VIN.n378 VIN.n376 23.0287
R3344 VIN.n376 VIN.t328 2.87903
R3345 VIN.t328 VIN.n374 20.1502
R3346 VIN.n374 VIN.n372 23.0287
R3347 VIN.n372 VIN.n370 23.0287
R3348 VIN.n370 VIN.n368 23.0287
R3349 VIN.n368 VIN.n366 23.0287
R3350 VIN.n366 VIN.n364 23.0287
R3351 VIN.n364 VIN.n362 23.0287
R3352 VIN.n362 VIN.n128 41.5482
R3353 VIN.n503 VIN.n501 1.7017
R3354 VIN.n503 VIN.n499 1.7017
R3355 VIN.n499 VIN.n502 0.0406087
R3356 VIN.n502 VIN.n497 0.657891
R3357 VIN.n497 VIN.n496 0.454413
R3358 VIN.n496 VIN.n495 0.558109
R3359 VIN.n502 VIN.t241 14.3142
R3360 VIN.n501 VIN.t239 14.3543
R3361 VIN.n501 VIN.n500 1.24778
R3362 VIN.n500 VIN.t221 7.04633
R3363 VIN.n500 VIN.t222 7.04633
R3364 VIN.n500 VIN.t219 23.443
R3365 VIN.n499 VIN.n498 1.24778
R3366 VIN.n498 VIN.t233 7.04633
R3367 VIN.n498 VIN.t234 7.04633
R3368 VIN.n498 VIN.t231 23.443
R3369 VIN.n497 VIN.t261 2.43584
R3370 VIN.n496 VIN.t263 2.4368
R3371 VIN.n495 VIN.t265 2.4368
R3372 VIN.n495 VIN.t329 2.99441
R3373 VIN.n492 VIN.n489 0.543435
R3374 VIN.n492 VIN.n490 0.543435
R3375 VIN.n490 VIN.n491 0.652022
R3376 VIN.n491 VIN.t229 78.6117
R3377 VIN.n490 VIN.t227 78.6117
R3378 VIN.n489 VIN.t225 78.6117
R3379 VIN.n489 VIN.t223 79.2632
R3380 VIN.n491 VIN.t117 10.4191
R3381 VIN.n78 VIN.n327 5.02925
R3382 VIN.n330 VIN.n78 1.09019
R3383 VIN.n329 VIN.n330 0.214769
R3384 VIN.n328 VIN.n329 0.214769
R3385 VIN.n5 VIN.n328 0.53751
R3386 VIN.n72 VIN.n293 5.02925
R3387 VIN.n296 VIN.n72 1.09019
R3388 VIN.n295 VIN.n296 0.214769
R3389 VIN.n294 VIN.n295 0.214769
R3390 VIN.n3 VIN.n294 0.53751
R3391 VIN.n258 VIN.n260 8.6675
R3392 VIN.n260 VIN.n262 1.2821
R3393 VIN.n130 VIN.n262 8.6675
R3394 VIN.n262 VIN.n264 6.44229
R3395 VIN.n264 VIN.t124 0.7845
R3396 VIN.n264 VIN.t256 0.7845
R3397 VIN.n262 VIN.n263 12.3015
R3398 VIN.n263 VIN.t80 0.7845
R3399 VIN.n263 VIN.t23 0.7845
R3400 VIN.n260 VIN.n261 12.3015
R3401 VIN.n261 VIN.t35 0.7845
R3402 VIN.n261 VIN.t66 0.7845
R3403 VIN.n260 VIN.n259 6.44229
R3404 VIN.n259 VIN.t38 0.7845
R3405 VIN.n259 VIN.t67 0.7845
R3406 VIN.n87 VIN.n84 1.09019
R3407 VIN.n86 VIN.n87 0.214769
R3408 VIN.n85 VIN.n86 0.214769
R3409 VIN.n7 VIN.n85 0.53751
R3410 VIN.n82 VIN.n79 1.99019
R3411 VIN.n81 VIN.n82 0.214769
R3412 VIN.n80 VIN.n81 0.214769
R3413 VIN.n6 VIN.n80 0.53751
R3414 VIN.n76 VIN.n73 1.99019
R3415 VIN.n75 VIN.n76 0.214769
R3416 VIN.n74 VIN.n75 0.214769
R3417 VIN.n4 VIN.n74 0.53751
R3418 VIN.n70 VIN.n67 1.99019
R3419 VIN.n69 VIN.n70 0.214769
R3420 VIN.n68 VIN.n69 0.214769
R3421 VIN.n2 VIN.n68 0.53751
R3422 VIN.n55 VIN.n53 1.8005
R3423 VIN.n55 VIN.n54 0.214769
R3424 VIN.n9 VIN.n55 0.53751
R3425 VIN.n45 VIN.n44 5.96923
R3426 VIN.n44 VIN.t147 0.653833
R3427 VIN.n44 VIN.t146 0.653833
R3428 VIN.n43 VIN.t143 6.62256
R3429 VIN.n31 VIN.n30 5.96923
R3430 VIN.n30 VIN.t128 0.653833
R3431 VIN.n30 VIN.t126 0.653833
R3432 VIN.n29 VIN.t130 6.62256
R3433 VIN.n17 VIN.n16 5.96923
R3434 VIN.n16 VIN.t259 0.653833
R3435 VIN.n16 VIN.t140 0.653833
R3436 VIN.n15 VIN.t137 6.62256
R3437 VIN.n1 VIN.n0 11.6088
R3438 VIN.n0 VIN.t19 16.9519
R3439 VIN.n0 VIN.t60 18.3635
R3440 VSS VSS.n1 0.0110333
R3441 VSS.n1 VSS.n0 0.365833
R3442 VSS.n0 VSS.n2 0.0610333
R3443 VSS.n2 VSS.n3 0.295067
R3444 VSS.n3 VSS.n4 0.0452667
R3445 VSS.n4 VSS.n5 0.0453
R3446 VSS.n5 VSS.n6 0.0452667
R3447 VSS.n6 VSS.n7 0.0453
R3448 VSS.n7 VSS.n8 14.1108
R3449 VSS.n8 VSS.n786 4.41095
R3450 VSS.n8 VSS.n785 1037.5
R3451 VSS.n9 VSS.n164 5.2005
R3452 VSS.n10 VSS.n9 5.2005
R3453 VSS.n11 VSS.n167 5.2005
R3454 VSS.n12 VSS.n11 5.2005
R3455 VSS.n13 VSS.n170 5.2005
R3456 VSS.n14 VSS.n13 5.2005
R3457 VSS.n15 VSS.n173 5.2005
R3458 VSS.n16 VSS.n15 5.2005
R3459 VSS.n17 VSS.n176 5.2005
R3460 VSS.n18 VSS.n17 5.2005
R3461 VSS.n19 VSS.n179 5.2005
R3462 VSS.n20 VSS.n19 5.2005
R3463 VSS.n21 VSS.n182 5.2005
R3464 VSS.n22 VSS.n21 5.2005
R3465 VSS.n23 VSS.n185 5.2005
R3466 VSS.n24 VSS.n23 5.2005
R3467 VSS.n25 VSS.n188 5.2005
R3468 VSS.n26 VSS.n25 5.2005
R3469 VSS.n27 VSS.n191 5.2005
R3470 VSS.n28 VSS.n27 5.2005
R3471 VSS.n29 VSS.n194 5.2005
R3472 VSS.n30 VSS.n29 5.2005
R3473 VSS.n31 VSS.n197 5.2005
R3474 VSS.n32 VSS.n31 5.2005
R3475 VSS.n33 VSS.n200 5.2005
R3476 VSS.n34 VSS.n33 5.2005
R3477 VSS.n35 VSS.n203 5.2005
R3478 VSS.n36 VSS.n35 5.2005
R3479 VSS.n37 VSS.n206 5.2005
R3480 VSS.n38 VSS.n37 5.2005
R3481 VSS.n39 VSS.n209 5.2005
R3482 VSS.n40 VSS.n39 5.2005
R3483 VSS.n41 VSS.n212 5.2005
R3484 VSS.n42 VSS.n41 5.2005
R3485 VSS.n43 VSS.n215 5.2005
R3486 VSS.n44 VSS.n43 5.2005
R3487 VSS.n45 VSS.n218 5.2005
R3488 VSS.n46 VSS.n45 5.2005
R3489 VSS.n47 VSS.n221 5.2005
R3490 VSS.n48 VSS.n47 5.2005
R3491 VSS.n49 VSS.n224 5.2005
R3492 VSS.n50 VSS.n49 5.2005
R3493 VSS.n51 VSS.n227 5.2005
R3494 VSS.n52 VSS.n51 5.2005
R3495 VSS.n53 VSS.n230 5.2005
R3496 VSS.n54 VSS.n53 5.2005
R3497 VSS.n55 VSS.n233 5.2005
R3498 VSS.n56 VSS.n55 5.2005
R3499 VSS.n57 VSS.n236 5.2005
R3500 VSS.n58 VSS.n57 5.2005
R3501 VSS.n59 VSS.n239 5.2005
R3502 VSS.n60 VSS.n59 5.2005
R3503 VSS.n61 VSS.n242 5.2005
R3504 VSS.n62 VSS.n61 5.2005
R3505 VSS.n63 VSS.n245 5.2005
R3506 VSS.n64 VSS.n63 5.2005
R3507 VSS.n65 VSS.n248 5.2005
R3508 VSS.n66 VSS.n65 5.2005
R3509 VSS.n67 VSS.n251 5.2005
R3510 VSS.n68 VSS.n67 5.2005
R3511 VSS.n69 VSS.n254 5.2005
R3512 VSS.n70 VSS.n69 5.2005
R3513 VSS.n71 VSS.n257 5.2005
R3514 VSS.n72 VSS.n71 5.2005
R3515 VSS.n73 VSS.n260 5.2005
R3516 VSS.n74 VSS.n73 5.2005
R3517 VSS.n75 VSS.n263 5.2005
R3518 VSS.n76 VSS.n75 5.2005
R3519 VSS.n77 VSS.n266 5.2005
R3520 VSS.n78 VSS.n77 5.2005
R3521 VSS.n79 VSS.n269 5.2005
R3522 VSS.n80 VSS.n79 5.2005
R3523 VSS.n81 VSS.n272 5.2005
R3524 VSS.n82 VSS.n81 5.2005
R3525 VSS.n83 VSS.n275 5.2005
R3526 VSS.n84 VSS.n83 5.2005
R3527 VSS.n85 VSS.n278 5.2005
R3528 VSS.n86 VSS.n85 5.2005
R3529 VSS.n87 VSS.n281 5.2005
R3530 VSS.n88 VSS.n87 5.2005
R3531 VSS.n89 VSS.n284 5.2005
R3532 VSS.n90 VSS.n89 5.2005
R3533 VSS.n91 VSS.n287 5.2005
R3534 VSS.n92 VSS.n91 5.2005
R3535 VSS.n93 VSS.n290 5.2005
R3536 VSS.n94 VSS.n93 5.2005
R3537 VSS.n95 VSS.n293 5.2005
R3538 VSS.n96 VSS.n95 5.2005
R3539 VSS.n97 VSS.n296 5.2005
R3540 VSS.n98 VSS.n97 5.2005
R3541 VSS.n99 VSS.n299 5.2005
R3542 VSS.n489 VSS.n99 5.2005
R3543 VSS.n100 VSS.n302 5.2005
R3544 VSS.n101 VSS.n100 5.2005
R3545 VSS.n102 VSS.n305 5.2005
R3546 VSS.n103 VSS.n102 5.2005
R3547 VSS.n104 VSS.n308 5.2005
R3548 VSS.n105 VSS.n104 5.2005
R3549 VSS.n106 VSS.n311 5.2005
R3550 VSS.n107 VSS.n106 5.2005
R3551 VSS.n108 VSS.n314 5.2005
R3552 VSS.n109 VSS.n108 5.2005
R3553 VSS.n110 VSS.n317 5.2005
R3554 VSS.n111 VSS.n110 5.2005
R3555 VSS.n112 VSS.n320 5.2005
R3556 VSS.n113 VSS.n112 5.2005
R3557 VSS.n114 VSS.n323 5.2005
R3558 VSS.n115 VSS.n114 5.2005
R3559 VSS.n116 VSS.n326 5.2005
R3560 VSS.n117 VSS.n116 5.2005
R3561 VSS.n118 VSS.n329 5.2005
R3562 VSS.n119 VSS.n118 5.2005
R3563 VSS.n120 VSS.n332 5.2005
R3564 VSS.n121 VSS.n120 5.2005
R3565 VSS.n122 VSS.n335 5.2005
R3566 VSS.n123 VSS.n122 5.2005
R3567 VSS.n124 VSS.n338 5.2005
R3568 VSS.n125 VSS.n124 5.2005
R3569 VSS.n126 VSS.n341 5.2005
R3570 VSS.n127 VSS.n126 5.2005
R3571 VSS.n128 VSS.n344 5.2005
R3572 VSS.n129 VSS.n128 5.2005
R3573 VSS.n130 VSS.n347 5.2005
R3574 VSS.n131 VSS.n130 5.2005
R3575 VSS.n132 VSS.n350 5.2005
R3576 VSS.n133 VSS.n132 5.2005
R3577 VSS.n134 VSS.n353 5.2005
R3578 VSS.n135 VSS.n134 5.2005
R3579 VSS.n137 VSS.n136 0.0758623
R3580 VSS.n138 VSS.n137 0.0758623
R3581 VSS.n139 VSS.n140 0.0655
R3582 VSS.n140 VSS.n142 0.0655
R3583 VSS.n162 VSS.n161 0.0758623
R3584 VSS.n163 VSS.n162 0.0758623
R3585 VSS.n164 VSS.n165 5.2005
R3586 VSS.n165 VSS.n166 5.2005
R3587 VSS.n167 VSS.n168 5.2005
R3588 VSS.n168 VSS.n169 5.2005
R3589 VSS.n170 VSS.n171 5.2005
R3590 VSS.n171 VSS.n172 5.2005
R3591 VSS.n173 VSS.n174 5.2005
R3592 VSS.n174 VSS.n175 5.2005
R3593 VSS.n176 VSS.n177 5.2005
R3594 VSS.n177 VSS.n178 5.2005
R3595 VSS.n179 VSS.n180 5.2005
R3596 VSS.n180 VSS.n181 5.2005
R3597 VSS.n182 VSS.n183 5.2005
R3598 VSS.n183 VSS.n184 5.2005
R3599 VSS.n185 VSS.n186 5.2005
R3600 VSS.n186 VSS.n187 5.2005
R3601 VSS.n188 VSS.n189 5.2005
R3602 VSS.n189 VSS.n190 5.2005
R3603 VSS.n191 VSS.n192 5.2005
R3604 VSS.n192 VSS.n193 5.2005
R3605 VSS.n194 VSS.n195 5.2005
R3606 VSS.n195 VSS.n196 5.2005
R3607 VSS.n197 VSS.n198 5.2005
R3608 VSS.n198 VSS.n199 5.2005
R3609 VSS.n200 VSS.n201 5.2005
R3610 VSS.n201 VSS.n202 5.2005
R3611 VSS.n203 VSS.n204 5.2005
R3612 VSS.n204 VSS.n205 5.2005
R3613 VSS.n206 VSS.n207 5.2005
R3614 VSS.n207 VSS.n208 5.2005
R3615 VSS.n209 VSS.n210 5.2005
R3616 VSS.n210 VSS.n211 5.2005
R3617 VSS.n212 VSS.n213 5.2005
R3618 VSS.n213 VSS.n214 5.2005
R3619 VSS.n215 VSS.n216 5.2005
R3620 VSS.n216 VSS.n217 5.2005
R3621 VSS.n218 VSS.n219 5.2005
R3622 VSS.n219 VSS.n220 5.2005
R3623 VSS.n221 VSS.n222 5.2005
R3624 VSS.n222 VSS.n223 5.2005
R3625 VSS.n224 VSS.n225 5.2005
R3626 VSS.n225 VSS.n226 5.2005
R3627 VSS.n227 VSS.n228 5.2005
R3628 VSS.n228 VSS.n229 5.2005
R3629 VSS.n230 VSS.n231 5.2005
R3630 VSS.n231 VSS.n232 5.2005
R3631 VSS.n233 VSS.n234 5.2005
R3632 VSS.n234 VSS.n235 5.2005
R3633 VSS.n236 VSS.n237 5.2005
R3634 VSS.n237 VSS.n238 5.2005
R3635 VSS.n239 VSS.n240 5.2005
R3636 VSS.n240 VSS.n241 5.2005
R3637 VSS.n242 VSS.n243 5.2005
R3638 VSS.n243 VSS.n244 5.2005
R3639 VSS.n245 VSS.n246 5.2005
R3640 VSS.n246 VSS.n247 5.2005
R3641 VSS.n248 VSS.n249 5.2005
R3642 VSS.n249 VSS.n250 5.2005
R3643 VSS.n251 VSS.n252 5.2005
R3644 VSS.n252 VSS.n253 5.2005
R3645 VSS.n254 VSS.n255 5.2005
R3646 VSS.n255 VSS.n256 5.2005
R3647 VSS.n257 VSS.n258 5.2005
R3648 VSS.n258 VSS.n259 5.2005
R3649 VSS.n260 VSS.n261 5.2005
R3650 VSS.n261 VSS.n262 5.2005
R3651 VSS.n263 VSS.n264 5.2005
R3652 VSS.n264 VSS.n265 5.2005
R3653 VSS.n266 VSS.n267 5.2005
R3654 VSS.n267 VSS.n268 5.2005
R3655 VSS.n269 VSS.n270 5.2005
R3656 VSS.n270 VSS.n271 5.2005
R3657 VSS.n272 VSS.n273 5.2005
R3658 VSS.n273 VSS.n274 5.2005
R3659 VSS.n275 VSS.n276 5.2005
R3660 VSS.n276 VSS.n277 5.2005
R3661 VSS.n278 VSS.n279 5.2005
R3662 VSS.n279 VSS.n280 5.2005
R3663 VSS.n281 VSS.n282 5.2005
R3664 VSS.n282 VSS.n283 5.2005
R3665 VSS.n284 VSS.n285 5.2005
R3666 VSS.n285 VSS.n286 5.2005
R3667 VSS.n287 VSS.n288 5.2005
R3668 VSS.n288 VSS.n289 5.2005
R3669 VSS.n290 VSS.n291 5.2005
R3670 VSS.n291 VSS.n292 5.2005
R3671 VSS.n293 VSS.n294 5.2005
R3672 VSS.n294 VSS.n295 5.2005
R3673 VSS.n296 VSS.n297 5.2005
R3674 VSS.n297 VSS.n298 5.2005
R3675 VSS.n299 VSS.n300 5.2005
R3676 VSS.n300 VSS.n301 5.2005
R3677 VSS.n302 VSS.n303 5.2005
R3678 VSS.n303 VSS.n304 5.2005
R3679 VSS.n305 VSS.n306 5.2005
R3680 VSS.n306 VSS.n307 5.2005
R3681 VSS.n308 VSS.n309 5.2005
R3682 VSS.n309 VSS.n310 5.2005
R3683 VSS.n311 VSS.n312 5.2005
R3684 VSS.n312 VSS.n313 5.2005
R3685 VSS.n314 VSS.n315 5.2005
R3686 VSS.n315 VSS.n316 5.2005
R3687 VSS.n317 VSS.n318 5.2005
R3688 VSS.n318 VSS.n319 5.2005
R3689 VSS.n320 VSS.n321 5.2005
R3690 VSS.n321 VSS.n322 5.2005
R3691 VSS.n323 VSS.n324 5.2005
R3692 VSS.n324 VSS.n325 5.2005
R3693 VSS.n326 VSS.n327 5.2005
R3694 VSS.n327 VSS.n328 5.2005
R3695 VSS.n329 VSS.n330 5.2005
R3696 VSS.n330 VSS.n331 5.2005
R3697 VSS.n332 VSS.n333 5.2005
R3698 VSS.n333 VSS.n334 5.2005
R3699 VSS.n335 VSS.n336 5.2005
R3700 VSS.n336 VSS.n337 5.2005
R3701 VSS.n338 VSS.n339 5.2005
R3702 VSS.n339 VSS.n340 5.2005
R3703 VSS.n341 VSS.n342 5.2005
R3704 VSS.n342 VSS.n343 5.2005
R3705 VSS.n344 VSS.n345 5.2005
R3706 VSS.n345 VSS.n346 5.2005
R3707 VSS.n347 VSS.n348 5.2005
R3708 VSS.n348 VSS.n349 5.2005
R3709 VSS.n350 VSS.n351 5.2005
R3710 VSS.n351 VSS.n352 5.2005
R3711 VSS.n353 VSS.n356 5.2005
R3712 VSS.n356 VSS.n357 5.2005
R3713 VSS.n136 VSS.n509 42.0672
R3714 VSS.n136 VSS.n353 100.96
R3715 VSS.n353 VSS.n350 56.0894
R3716 VSS.n350 VSS.n347 56.0894
R3717 VSS.n347 VSS.n344 56.0894
R3718 VSS.n344 VSS.n341 56.0894
R3719 VSS.n341 VSS.n338 56.0894
R3720 VSS.n338 VSS.n335 56.0894
R3721 VSS.n335 VSS.n332 56.0894
R3722 VSS.n332 VSS.n329 56.0894
R3723 VSS.n329 VSS.n326 56.0894
R3724 VSS.n326 VSS.n323 56.0894
R3725 VSS.n323 VSS.n320 56.0894
R3726 VSS.n320 VSS.t63 46.2738
R3727 VSS.n317 VSS.t63 9.81605
R3728 VSS.n317 VSS.n314 56.0894
R3729 VSS.n314 VSS.n311 56.0894
R3730 VSS.n311 VSS.t21 4.20717
R3731 VSS.t21 VSS.n308 51.8827
R3732 VSS.n308 VSS.n305 56.0894
R3733 VSS.n305 VSS.n302 56.0894
R3734 VSS.n302 VSS.n299 56.0894
R3735 VSS.n299 VSS.t100 7.71272
R3736 VSS.t100 VSS.n296 48.3772
R3737 VSS.n296 VSS.n293 56.0894
R3738 VSS.n293 VSS.t25 21.0338
R3739 VSS.t25 VSS.n290 35.056
R3740 VSS.n290 VSS.t41 37.8605
R3741 VSS.n287 VSS.t41 18.2294
R3742 VSS.n287 VSS.n284 56.0894
R3743 VSS.n284 VSS.n281 56.0894
R3744 VSS.n281 VSS.t58 46.2738
R3745 VSS.t45 VSS.t58 8.41383
R3746 VSS.n278 VSS.t45 1.40272
R3747 VSS.n278 VSS.n275 56.0894
R3748 VSS.n275 VSS.t80 23.8383
R3749 VSS.t80 VSS.n272 32.2516
R3750 VSS.n272 VSS.t5 49.0783
R3751 VSS.n269 VSS.t5 7.01161
R3752 VSS.n269 VSS.n266 56.0894
R3753 VSS.n266 VSS.t60 15.4249
R3754 VSS.t60 VSS.t66 2.80494
R3755 VSS.t66 VSS.n263 37.8605
R3756 VSS.n263 VSS.t91 43.4694
R3757 VSS.n260 VSS.t91 12.6205
R3758 VSS.n260 VSS.n139 28.0449
R3759 VSS.n139 VSS.n257 28.0449
R3760 VSS.n257 VSS.t82 12.6205
R3761 VSS.t82 VSS.n254 43.4694
R3762 VSS.n254 VSS.t0 37.8605
R3763 VSS.t61 VSS.t0 2.80494
R3764 VSS.n251 VSS.t61 15.4249
R3765 VSS.n251 VSS.n248 56.0894
R3766 VSS.n248 VSS.t7 7.01161
R3767 VSS.t7 VSS.n245 49.0783
R3768 VSS.n245 VSS.t74 32.2516
R3769 VSS.n242 VSS.t74 23.8383
R3770 VSS.n242 VSS.n239 56.0894
R3771 VSS.n239 VSS.t49 1.40272
R3772 VSS.t49 VSS.t59 8.41383
R3773 VSS.t59 VSS.n236 46.2738
R3774 VSS.n236 VSS.n233 56.0894
R3775 VSS.n233 VSS.n230 56.0894
R3776 VSS.n230 VSS.t53 18.2294
R3777 VSS.t53 VSS.n227 37.8605
R3778 VSS.n227 VSS.t27 35.056
R3779 VSS.n224 VSS.t27 21.0338
R3780 VSS.n224 VSS.n221 56.0894
R3781 VSS.n221 VSS.n218 56.0894
R3782 VSS.n218 VSS.n215 56.0894
R3783 VSS.n215 VSS.n212 56.0894
R3784 VSS.n212 VSS.n209 56.0894
R3785 VSS.n209 VSS.t29 51.8827
R3786 VSS.n206 VSS.t29 4.20717
R3787 VSS.n206 VSS.n203 56.0894
R3788 VSS.n203 VSS.t98 20.3327
R3789 VSS.t98 VSS.n200 35.7572
R3790 VSS.n200 VSS.n197 56.0894
R3791 VSS.n197 VSS.n194 56.0894
R3792 VSS.n194 VSS.t104 51.8827
R3793 VSS.n191 VSS.t104 4.20717
R3794 VSS.n191 VSS.n188 56.0894
R3795 VSS.n188 VSS.n185 56.0894
R3796 VSS.n185 VSS.n182 56.0894
R3797 VSS.n182 VSS.n179 56.0894
R3798 VSS.n179 VSS.n176 56.0894
R3799 VSS.n176 VSS.n173 56.0894
R3800 VSS.n173 VSS.n170 56.0894
R3801 VSS.n170 VSS.n167 56.0894
R3802 VSS.n167 VSS.n164 56.0894
R3803 VSS.n164 VSS.n161 100.96
R3804 VSS.n161 VSS.n786 276.238
R3805 VSS.n786 VSS.t106 96.7538
R3806 VSS.t106 VSS.n785 928.622
R3807 VSS.n509 VSS.n785 19659
R3808 VSS.n513 VSS.n512 0.0477727
R3809 VSS.n514 VSS.n513 0.0477727
R3810 VSS.n516 VSS.n515 0.0477727
R3811 VSS.n522 VSS.n516 0.0477727
R3812 VSS.n523 VSS.n578 5.2005
R3813 VSS.n524 VSS.n523 5.2005
R3814 VSS.n525 VSS.n581 5.2005
R3815 VSS.n732 VSS.n525 5.2005
R3816 VSS.n526 VSS.n583 5.2005
R3817 VSS.n527 VSS.n526 5.2005
R3818 VSS.n528 VSS.n586 5.2005
R3819 VSS.n529 VSS.n528 5.2005
R3820 VSS.n530 VSS.n589 5.2005
R3821 VSS.n531 VSS.n530 5.2005
R3822 VSS.n532 VSS.n592 5.2005
R3823 VSS.n533 VSS.n532 5.2005
R3824 VSS.n534 VSS.n595 5.2005
R3825 VSS.n535 VSS.n534 5.2005
R3826 VSS.n536 VSS.n598 5.2005
R3827 VSS.n537 VSS.n536 5.2005
R3828 VSS.n538 VSS.n601 5.2005
R3829 VSS.n539 VSS.n538 5.2005
R3830 VSS.n540 VSS.n604 5.2005
R3831 VSS.n541 VSS.n540 5.2005
R3832 VSS.n542 VSS.n607 5.2005
R3833 VSS.n543 VSS.n542 5.2005
R3834 VSS.n544 VSS.n610 5.2005
R3835 VSS.n545 VSS.n544 5.2005
R3836 VSS.n546 VSS.n613 5.2005
R3837 VSS.n547 VSS.n546 5.2005
R3838 VSS.n548 VSS.n616 5.2005
R3839 VSS.n549 VSS.n548 5.2005
R3840 VSS.n550 VSS.n619 5.2005
R3841 VSS.n551 VSS.n550 5.2005
R3842 VSS.n552 VSS.n622 5.2005
R3843 VSS.n553 VSS.n552 5.2005
R3844 VSS.n554 VSS.n625 5.2005
R3845 VSS.n555 VSS.n554 5.2005
R3846 VSS.n556 VSS.n628 5.2005
R3847 VSS.n557 VSS.n556 5.2005
R3848 VSS.n558 VSS.n631 5.2005
R3849 VSS.n559 VSS.n558 5.2005
R3850 VSS.n560 VSS.n634 5.2005
R3851 VSS.n561 VSS.n560 5.2005
R3852 VSS.n562 VSS.n637 5.2005
R3853 VSS.n563 VSS.n562 5.2005
R3854 VSS.n564 VSS.n640 5.2005
R3855 VSS.n565 VSS.n564 5.2005
R3856 VSS.n566 VSS.n643 5.2005
R3857 VSS.n567 VSS.n566 5.2005
R3858 VSS.n568 VSS.n646 5.2005
R3859 VSS.n569 VSS.n568 5.2005
R3860 VSS.n570 VSS.n649 5.2005
R3861 VSS.n571 VSS.n570 5.2005
R3862 VSS.n573 VSS.n572 0.2085
R3863 VSS.n574 VSS.n573 0.2085
R3864 VSS.n576 VSS.n575 0.2085
R3865 VSS.n577 VSS.n576 0.2085
R3866 VSS.n578 VSS.n579 5.2005
R3867 VSS.n579 VSS.n580 5.2005
R3868 VSS.n581 VSS.n582 5.2005
R3869 VSS.n582 VSS.n758 5.2005
R3870 VSS.n583 VSS.n584 5.2005
R3871 VSS.n584 VSS.n585 5.2005
R3872 VSS.n586 VSS.n587 5.2005
R3873 VSS.n587 VSS.n588 5.2005
R3874 VSS.n589 VSS.n590 5.2005
R3875 VSS.n590 VSS.n591 5.2005
R3876 VSS.n592 VSS.n593 5.2005
R3877 VSS.n593 VSS.n594 5.2005
R3878 VSS.n595 VSS.n596 5.2005
R3879 VSS.n596 VSS.n597 5.2005
R3880 VSS.n598 VSS.n599 5.2005
R3881 VSS.n599 VSS.n600 5.2005
R3882 VSS.n601 VSS.n602 5.2005
R3883 VSS.n602 VSS.n603 5.2005
R3884 VSS.n604 VSS.n605 5.2005
R3885 VSS.n605 VSS.n606 5.2005
R3886 VSS.n607 VSS.n608 5.2005
R3887 VSS.n608 VSS.n609 5.2005
R3888 VSS.n610 VSS.n611 5.2005
R3889 VSS.n611 VSS.n612 5.2005
R3890 VSS.n613 VSS.n614 5.2005
R3891 VSS.n614 VSS.n615 5.2005
R3892 VSS.n616 VSS.n617 5.2005
R3893 VSS.n617 VSS.n618 5.2005
R3894 VSS.n619 VSS.n620 5.2005
R3895 VSS.n620 VSS.n621 5.2005
R3896 VSS.n622 VSS.n623 5.2005
R3897 VSS.n623 VSS.n624 5.2005
R3898 VSS.n625 VSS.n626 5.2005
R3899 VSS.n626 VSS.n627 5.2005
R3900 VSS.n628 VSS.n629 5.2005
R3901 VSS.n629 VSS.n630 5.2005
R3902 VSS.n631 VSS.n632 5.2005
R3903 VSS.n632 VSS.n633 5.2005
R3904 VSS.n634 VSS.n635 5.2005
R3905 VSS.n635 VSS.n636 5.2005
R3906 VSS.n637 VSS.n638 5.2005
R3907 VSS.n638 VSS.n639 5.2005
R3908 VSS.n640 VSS.n641 5.2005
R3909 VSS.n641 VSS.n642 5.2005
R3910 VSS.n643 VSS.n644 5.2005
R3911 VSS.n644 VSS.n645 5.2005
R3912 VSS.n646 VSS.n647 5.2005
R3913 VSS.n647 VSS.n648 5.2005
R3914 VSS.n649 VSS.n650 5.2005
R3915 VSS.n650 VSS.n651 5.2005
R3916 VSS.n652 VSS.n661 5.2005
R3917 VSS.n653 VSS.n652 5.2005
R3918 VSS.n654 VSS.n664 5.2005
R3919 VSS.n777 VSS.n654 5.2005
R3920 VSS.n656 VSS.n655 0.3255
R3921 VSS.n657 VSS.n656 0.3255
R3922 VSS.n659 VSS.n658 0.3255
R3923 VSS.n660 VSS.n659 0.3255
R3924 VSS.n661 VSS.n662 5.2005
R3925 VSS.n662 VSS.n663 5.2005
R3926 VSS.n664 VSS.n665 5.2005
R3927 VSS.n665 VSS.n780 5.2005
R3928 VSS.n666 VSS.n675 5.2005
R3929 VSS.n667 VSS.n666 5.2005
R3930 VSS.n668 VSS.n678 5.2005
R3931 VSS.n769 VSS.n668 5.2005
R3932 VSS.n670 VSS.n669 0.6505
R3933 VSS.n671 VSS.n670 0.6505
R3934 VSS.n673 VSS.n672 0.6505
R3935 VSS.n674 VSS.n673 0.6505
R3936 VSS.n675 VSS.n676 5.2005
R3937 VSS.n677 VSS.n676 5.2005
R3938 VSS.n678 VSS.n679 5.2005
R3939 VSS.n772 VSS.n679 5.2005
R3940 VSS.n680 VSS.n689 5.2005
R3941 VSS.n681 VSS.n680 5.2005
R3942 VSS.n682 VSS.n692 5.2005
R3943 VSS.n697 VSS.n682 5.2005
R3944 VSS.n684 VSS.n683 0.3255
R3945 VSS.n685 VSS.n684 0.3255
R3946 VSS.n687 VSS.n686 0.3255
R3947 VSS.n688 VSS.n687 0.3255
R3948 VSS.n689 VSS.n690 5.2005
R3949 VSS.n690 VSS.n691 5.2005
R3950 VSS.n692 VSS.n693 5.2005
R3951 VSS.n693 VSS.n694 5.2005
R3952 VSS.n510 VSS.t77 47.5674
R3953 VSS.n572 VSS.t77 16.6047
R3954 VSS.n572 VSS.n649 30.5308
R3955 VSS.n649 VSS.t13 16.3369
R3956 VSS.n646 VSS.t13 5.08888
R3957 VSS.n646 VSS.n643 21.4252
R3958 VSS.n643 VSS.n640 21.4252
R3959 VSS.n640 VSS.n637 21.4252
R3960 VSS.n637 VSS.t68 1.33955
R3961 VSS.t68 VSS.n634 20.0862
R3962 VSS.n634 VSS.n631 21.4252
R3963 VSS.n631 VSS.n628 21.4252
R3964 VSS.n628 VSS.t10 5.08888
R3965 VSS.t10 VSS.n625 16.3369
R3966 VSS.n625 VSS.n622 21.4252
R3967 VSS.n622 VSS.n619 21.4252
R3968 VSS.n619 VSS.t70 8.83821
R3969 VSS.t70 VSS.n616 12.5875
R3970 VSS.n616 VSS.n613 21.4252
R3971 VSS.n613 VSS.n610 21.4252
R3972 VSS.n610 VSS.t87 12.5875
R3973 VSS.n607 VSS.t87 8.83821
R3974 VSS.n607 VSS.n604 21.4252
R3975 VSS.n604 VSS.n601 21.4252
R3976 VSS.n601 VSS.t56 16.3369
R3977 VSS.n598 VSS.t56 5.08888
R3978 VSS.n598 VSS.n595 21.4252
R3979 VSS.n595 VSS.n592 21.4252
R3980 VSS.n592 VSS.t93 20.0862
R3981 VSS.n589 VSS.t93 1.33955
R3982 VSS.n589 VSS.n586 21.4252
R3983 VSS.n586 VSS.n583 21.4252
R3984 VSS.n583 VSS.n581 21.4252
R3985 VSS.n581 VSS.t17 5.08888
R3986 VSS.t17 VSS.n578 16.3369
R3987 VSS.n578 VSS.n575 30.5308
R3988 VSS.n575 VSS.n669 64.8104
R3989 VSS.n669 VSS.n678 36.6904
R3990 VSS.n678 VSS.t102 10.7129
R3991 VSS.t102 VSS.n675 10.7129
R3992 VSS.n675 VSS.n672 36.6904
R3993 VSS.n672 VSS.n655 64.8104
R3994 VSS.n655 VSS.n664 36.6904
R3995 VSS.n664 VSS.t72 10.7129
R3996 VSS.t72 VSS.n661 10.7129
R3997 VSS.n661 VSS.n658 36.6904
R3998 VSS.n658 VSS.n683 64.8104
R3999 VSS.n683 VSS.n692 36.6904
R4000 VSS.n692 VSS.t9 10.7129
R4001 VSS.t9 VSS.n689 10.7129
R4002 VSS.n689 VSS.n686 36.6904
R4003 VSS.n686 VSS.n511 53.5624
R4004 VSS.n511 VSS.n512 339.582
R4005 VSS.n512 VSS.t2 50.3487
R4006 VSS.t2 VSS.t78 64.2747
R4007 VSS.t78 VSS.t97 64.2747
R4008 VSS.t97 VSS.t95 64.2747
R4009 VSS.t95 VSS.t73 64.2747
R4010 VSS.t73 VSS.t89 64.2747
R4011 VSS.t89 VSS.t76 64.2747
R4012 VSS.t76 VSS.t79 64.2747
R4013 VSS.t107 VSS.t79 64.2747
R4014 VSS.t62 VSS.t107 64.2747
R4015 VSS.t90 VSS.t62 64.2747
R4016 VSS.t65 VSS.t90 64.2747
R4017 VSS.t84 VSS.t65 64.2747
R4018 VSS.n515 VSS.t84 50.3487
R4019 VSS.n515 VSS.n509 94.805
R4020 VSS.n695 VSS.n691 4.5005
R4021 VSS.n784 VSS.n694 4.5005
R4022 VSS.n694 VSS.n691 0.1445
R4023 VSS.n784 VSS.n695 0.1445
R4024 VSS.n688 VSS.n695 5.63665
R4025 VSS.n696 VSS.n688 5.63665
R4026 VSS.n696 VSS.n681 4.5005
R4027 VSS.n698 VSS.n697 4.5005
R4028 VSS.n699 VSS.n698 0.1247
R4029 VSS.n698 VSS.n696 0.1445
R4030 VSS.n783 VSS.n699 11.1605
R4031 VSS.n767 VSS.n707 5.18971
R4032 VSS.n707 VSS.n775 0.448132
R4033 VSS.n775 VSS.n783 1.41208
R4034 VSS.n783 VSS.n782 9.74892
R4035 VSS.n776 VSS.n653 4.5005
R4036 VSS.n778 VSS.n777 4.5005
R4037 VSS.n782 VSS.n778 0.1247
R4038 VSS.n778 VSS.n776 0.1445
R4039 VSS.n776 VSS.n660 5.63665
R4040 VSS.n660 VSS.n779 5.63665
R4041 VSS.n779 VSS.n663 4.5005
R4042 VSS.n781 VSS.n780 4.5005
R4043 VSS.n781 VSS.n779 0.1445
R4044 VSS.n657 VSS.n781 5.63665
R4045 VSS.n782 VSS.n657 5.51245
R4046 VSS.n780 VSS.n663 0.1445
R4047 VSS.n777 VSS.n653 0.1445
R4048 VSS.n775 VSS.n774 10.2214
R4049 VSS.n768 VSS.n667 4.5005
R4050 VSS.n770 VSS.n769 4.5005
R4051 VSS.n774 VSS.n770 0.1247
R4052 VSS.n770 VSS.n768 0.1445
R4053 VSS.n768 VSS.n674 5.24633
R4054 VSS.n674 VSS.n771 5.24633
R4055 VSS.n677 VSS.n771 4.5005
R4056 VSS.n773 VSS.n772 4.5005
R4057 VSS.n773 VSS.n771 0.1445
R4058 VSS.n671 VSS.n773 5.24633
R4059 VSS.n774 VSS.n671 5.12213
R4060 VSS.n772 VSS.n677 0.1445
R4061 VSS.n769 VSS.n667 0.1445
R4062 VSS.n1 VSS.n767 7.95944
R4063 VSS.n767 VSS.n766 9.27524
R4064 VSS.n524 VSS.n708 4.5005
R4065 VSS.n709 VSS.n571 4.5005
R4066 VSS.n710 VSS.n569 4.5005
R4067 VSS.n711 VSS.n567 4.5005
R4068 VSS.n712 VSS.n565 4.5005
R4069 VSS.n713 VSS.n563 4.5005
R4070 VSS.n714 VSS.n561 4.5005
R4071 VSS.n715 VSS.n559 4.5005
R4072 VSS.n557 VSS.n716 4.5005
R4073 VSS.n717 VSS.n555 4.5005
R4074 VSS.n718 VSS.n553 4.5005
R4075 VSS.n719 VSS.n551 4.5005
R4076 VSS.n720 VSS.n549 4.5005
R4077 VSS.n721 VSS.n547 4.5005
R4078 VSS.n722 VSS.n545 4.5005
R4079 VSS.n723 VSS.n543 4.5005
R4080 VSS.n541 VSS.n724 4.5005
R4081 VSS.n539 VSS.n725 4.5005
R4082 VSS.n537 VSS.n726 4.5005
R4083 VSS.n535 VSS.n727 4.5005
R4084 VSS.n533 VSS.n728 4.5005
R4085 VSS.n531 VSS.n729 4.5005
R4086 VSS.n529 VSS.n730 4.5005
R4087 VSS.n527 VSS.n731 4.5005
R4088 VSS.n732 VSS.n733 4.5005
R4089 VSS.n766 VSS.n709 0.0653
R4090 VSS.n709 VSS.n710 0.1445
R4091 VSS.n710 VSS.n711 0.1445
R4092 VSS.n711 VSS.n712 0.1445
R4093 VSS.n712 VSS.n713 0.1445
R4094 VSS.n713 VSS.n714 0.1445
R4095 VSS.n714 VSS.n715 0.1445
R4096 VSS.n715 VSS.n716 0.1445
R4097 VSS.n716 VSS.n717 0.1445
R4098 VSS.n717 VSS.n718 0.1445
R4099 VSS.n718 VSS.n719 0.1445
R4100 VSS.n719 VSS.n720 0.1445
R4101 VSS.n720 VSS.n721 0.1445
R4102 VSS.n721 VSS.n722 0.1445
R4103 VSS.n722 VSS.n723 0.1445
R4104 VSS.n723 VSS.n724 0.1445
R4105 VSS.n724 VSS.n725 0.1445
R4106 VSS.n725 VSS.n726 0.1445
R4107 VSS.n726 VSS.n727 0.1445
R4108 VSS.n727 VSS.n728 0.1445
R4109 VSS.n728 VSS.n729 0.1445
R4110 VSS.n729 VSS.n730 0.1445
R4111 VSS.n730 VSS.n731 0.1445
R4112 VSS.n731 VSS.n733 0.1445
R4113 VSS.n733 VSS.n708 0.1445
R4114 VSS.n708 VSS.n763 5.32036
R4115 VSS.n765 VSS.n764 0.113978
R4116 VSS.n763 VSS.n765 0.229413
R4117 VSS.n764 VSS.t18 2.6861
R4118 VSS.n765 VSS.t19 2.57262
R4119 VSS.n764 VSS.t16 30.2232
R4120 VSS.n763 VSS.n577 0.576696
R4121 VSS.n577 VSS.n734 5.98656
R4122 VSS.n734 VSS.n580 4.5005
R4123 VSS.n735 VSS.n651 4.5005
R4124 VSS.n736 VSS.n648 4.5005
R4125 VSS.n737 VSS.n645 4.5005
R4126 VSS.n642 VSS.n738 4.5005
R4127 VSS.n639 VSS.n739 4.5005
R4128 VSS.n636 VSS.n740 4.5005
R4129 VSS.n633 VSS.n741 4.5005
R4130 VSS.n742 VSS.n630 4.5005
R4131 VSS.n627 VSS.n743 4.5005
R4132 VSS.n624 VSS.n744 4.5005
R4133 VSS.n621 VSS.n745 4.5005
R4134 VSS.n746 VSS.n618 4.5005
R4135 VSS.n747 VSS.n615 4.5005
R4136 VSS.n612 VSS.n748 4.5005
R4137 VSS.n749 VSS.n609 4.5005
R4138 VSS.n750 VSS.n606 4.5005
R4139 VSS.n751 VSS.n603 4.5005
R4140 VSS.n752 VSS.n600 4.5005
R4141 VSS.n753 VSS.n597 4.5005
R4142 VSS.n754 VSS.n594 4.5005
R4143 VSS.n755 VSS.n591 4.5005
R4144 VSS.n756 VSS.n588 4.5005
R4145 VSS.n757 VSS.n585 4.5005
R4146 VSS.n758 VSS.n759 4.5005
R4147 VSS.n735 VSS.n736 0.1445
R4148 VSS.n736 VSS.n737 0.1445
R4149 VSS.n737 VSS.n738 0.1445
R4150 VSS.n738 VSS.n739 0.1445
R4151 VSS.n739 VSS.n740 0.1445
R4152 VSS.n740 VSS.n741 0.1445
R4153 VSS.n741 VSS.n742 0.1445
R4154 VSS.n742 VSS.n743 0.1445
R4155 VSS.n743 VSS.n744 0.1445
R4156 VSS.n744 VSS.n745 0.1445
R4157 VSS.n745 VSS.n746 0.1445
R4158 VSS.n746 VSS.n747 0.1445
R4159 VSS.n747 VSS.n748 0.1445
R4160 VSS.n748 VSS.n749 0.1445
R4161 VSS.n749 VSS.n750 0.1445
R4162 VSS.n750 VSS.n751 0.1445
R4163 VSS.n751 VSS.n752 0.1445
R4164 VSS.n752 VSS.n753 0.1445
R4165 VSS.n753 VSS.n754 0.1445
R4166 VSS.n754 VSS.n755 0.1445
R4167 VSS.n755 VSS.n756 0.1445
R4168 VSS.n756 VSS.n757 0.1445
R4169 VSS.n757 VSS.n759 0.1445
R4170 VSS.n759 VSS.n734 0.1445
R4171 VSS.n760 VSS.n574 0.576696
R4172 VSS.n574 VSS.n735 5.98656
R4173 VSS.n760 VSS.n762 0.229413
R4174 VSS.n762 VSS.n761 0.113978
R4175 VSS.n762 VSS.t14 2.57262
R4176 VSS.n761 VSS.t15 2.6861
R4177 VSS.n761 VSS.t12 30.2232
R4178 VSS.n766 VSS.n760 5.25556
R4179 VSS.n651 VSS.n648 0.1445
R4180 VSS.n648 VSS.n645 0.1445
R4181 VSS.n645 VSS.n642 0.1445
R4182 VSS.n642 VSS.n639 0.1445
R4183 VSS.n639 VSS.n636 0.1445
R4184 VSS.n636 VSS.n633 0.1445
R4185 VSS.n633 VSS.n630 0.1445
R4186 VSS.n630 VSS.n627 0.1445
R4187 VSS.n627 VSS.n624 0.1445
R4188 VSS.n624 VSS.n621 0.1445
R4189 VSS.n621 VSS.n618 0.1445
R4190 VSS.n618 VSS.n615 0.1445
R4191 VSS.n615 VSS.n612 0.1445
R4192 VSS.n612 VSS.n609 0.1445
R4193 VSS.n609 VSS.n606 0.1445
R4194 VSS.n606 VSS.n603 0.1445
R4195 VSS.n603 VSS.n600 0.1445
R4196 VSS.n600 VSS.n597 0.1445
R4197 VSS.n597 VSS.n594 0.1445
R4198 VSS.n594 VSS.n591 0.1445
R4199 VSS.n591 VSS.n588 0.1445
R4200 VSS.n588 VSS.n585 0.1445
R4201 VSS.n585 VSS.n758 0.1445
R4202 VSS.n758 VSS.n580 0.1445
R4203 VSS.n571 VSS.n569 0.1445
R4204 VSS.n569 VSS.n567 0.1445
R4205 VSS.n567 VSS.n565 0.1445
R4206 VSS.n565 VSS.n563 0.1445
R4207 VSS.n563 VSS.n561 0.1445
R4208 VSS.n561 VSS.n559 0.1445
R4209 VSS.n559 VSS.n557 0.1445
R4210 VSS.n557 VSS.n555 0.1445
R4211 VSS.n555 VSS.n553 0.1445
R4212 VSS.n553 VSS.n551 0.1445
R4213 VSS.n551 VSS.n549 0.1445
R4214 VSS.n549 VSS.n547 0.1445
R4215 VSS.n547 VSS.n545 0.1445
R4216 VSS.n545 VSS.n543 0.1445
R4217 VSS.n543 VSS.n541 0.1445
R4218 VSS.n541 VSS.n539 0.1445
R4219 VSS.n539 VSS.n537 0.1445
R4220 VSS.n537 VSS.n535 0.1445
R4221 VSS.n535 VSS.n533 0.1445
R4222 VSS.n533 VSS.n531 0.1445
R4223 VSS.n531 VSS.n529 0.1445
R4224 VSS.n529 VSS.n527 0.1445
R4225 VSS.n527 VSS.n732 0.1445
R4226 VSS.n732 VSS.n524 0.1445
R4227 VSS.n707 VSS.n706 12.6692
R4228 VSS.n706 VSS.n700 0.846026
R4229 VSS.n706 VSS.t103 24.0435
R4230 VSS.n702 VSS.n704 0.509711
R4231 VSS.n700 VSS.n702 5.53076
R4232 VSS.n704 VSS.n705 5.66671
R4233 VSS.n705 VSS.t57 7.16854
R4234 VSS.n705 VSS.t11 8.54014
R4235 VSS.n704 VSS.n703 4.7003
R4236 VSS.n703 VSS.t94 7.58919
R4237 VSS.n703 VSS.t69 9.87519
R4238 VSS.n702 VSS.n701 5.6147
R4239 VSS.n701 VSS.t88 8.00985
R4240 VSS.n701 VSS.t71 8.46705
R4241 VSS.n699 VSS.n685 5.51245
R4242 VSS.n685 VSS.n784 5.63665
R4243 VSS.n697 VSS.n681 0.1445
R4244 VSS.n693 VSS.n690 15.5561
R4245 VSS.n687 VSS.n690 112.293
R4246 VSS.n682 VSS.n680 15.5561
R4247 VSS.n680 VSS.n687 112.293
R4248 VSS.n682 VSS.n684 112.293
R4249 VSS.n684 VSS.n693 112.293
R4250 VSS.n679 VSS.n676 15.5561
R4251 VSS.n673 VSS.n676 73.5005
R4252 VSS.n668 VSS.n666 15.5561
R4253 VSS.n666 VSS.n673 73.5005
R4254 VSS.n668 VSS.n670 73.5005
R4255 VSS.n670 VSS.n679 73.5005
R4256 VSS.n665 VSS.n662 15.5561
R4257 VSS.n659 VSS.n662 112.293
R4258 VSS.n654 VSS.n652 15.5561
R4259 VSS.n652 VSS.n659 112.293
R4260 VSS.n654 VSS.n656 112.293
R4261 VSS.n656 VSS.n665 112.293
R4262 VSS.n650 VSS.n647 15.5561
R4263 VSS.n647 VSS.n644 15.5561
R4264 VSS.n644 VSS.n641 15.5561
R4265 VSS.n641 VSS.n638 15.5561
R4266 VSS.n638 VSS.n635 15.5561
R4267 VSS.n635 VSS.n632 15.5561
R4268 VSS.n632 VSS.n629 15.5561
R4269 VSS.n629 VSS.n626 15.5561
R4270 VSS.n626 VSS.n623 15.5561
R4271 VSS.n623 VSS.n620 15.5561
R4272 VSS.n620 VSS.n617 15.5561
R4273 VSS.n617 VSS.n614 15.5561
R4274 VSS.n614 VSS.n611 15.5561
R4275 VSS.n611 VSS.n608 15.5561
R4276 VSS.n608 VSS.n605 15.5561
R4277 VSS.n605 VSS.n602 15.5561
R4278 VSS.n602 VSS.n599 15.5561
R4279 VSS.n599 VSS.n596 15.5561
R4280 VSS.n596 VSS.n593 15.5561
R4281 VSS.n593 VSS.n590 15.5561
R4282 VSS.n590 VSS.n587 15.5561
R4283 VSS.n587 VSS.n584 15.5561
R4284 VSS.n584 VSS.n582 15.5561
R4285 VSS.n582 VSS.n579 15.5561
R4286 VSS.n576 VSS.n579 146.708
R4287 VSS.n570 VSS.n568 15.5561
R4288 VSS.n568 VSS.n566 15.5561
R4289 VSS.n566 VSS.n564 15.5561
R4290 VSS.n564 VSS.n562 15.5561
R4291 VSS.n562 VSS.n560 15.5561
R4292 VSS.n560 VSS.n558 15.5561
R4293 VSS.n558 VSS.n556 15.5561
R4294 VSS.n556 VSS.n554 15.5561
R4295 VSS.n554 VSS.n552 15.5561
R4296 VSS.n552 VSS.n550 15.5561
R4297 VSS.n550 VSS.n548 15.5561
R4298 VSS.n548 VSS.n546 15.5561
R4299 VSS.n546 VSS.n544 15.5561
R4300 VSS.n544 VSS.n542 15.5561
R4301 VSS.n542 VSS.n540 15.5561
R4302 VSS.n540 VSS.n538 15.5561
R4303 VSS.n538 VSS.n536 15.5561
R4304 VSS.n536 VSS.n534 15.5561
R4305 VSS.n534 VSS.n532 15.5561
R4306 VSS.n532 VSS.n530 15.5561
R4307 VSS.n530 VSS.n528 15.5561
R4308 VSS.n528 VSS.n526 15.5561
R4309 VSS.n526 VSS.n525 15.5561
R4310 VSS.n525 VSS.n523 15.5561
R4311 VSS.n523 VSS.n576 146.708
R4312 VSS.n570 VSS.n573 146.708
R4313 VSS.n573 VSS.n650 146.708
R4314 VSS.n521 VSS.n522 9.77528
R4315 VSS.n522 VSS.n517 9.77528
R4316 VSS.n521 VSS.t85 4.30565
R4317 VSS.n520 VSS.n521 13.0421
R4318 VSS.n0 VSS.n520 15.7554
R4319 VSS.n520 VSS.n519 0.303761
R4320 VSS.n519 VSS.t3 4.30565
R4321 VSS.n519 VSS.n514 9.77528
R4322 VSS.n514 VSS.n518 9.77528
R4323 VSS.n518 VSS.t4 4.30565
R4324 VSS.n517 VSS.n518 13.3909
R4325 VSS.n517 VSS.t86 4.30565
R4326 VSS.n516 VSS.n513 821.625
R4327 VSS.n510 VSS.n511 10.8247
R4328 VSS.n700 VSS.n510 20.1267
R4329 VSS.n358 VSS.n166 4.5005
R4330 VSS.n359 VSS.n357 4.5005
R4331 VSS.n360 VSS.n352 4.5005
R4332 VSS.n361 VSS.n349 4.5005
R4333 VSS.n362 VSS.n346 4.5005
R4334 VSS.n363 VSS.n343 4.5005
R4335 VSS.n364 VSS.n340 4.5005
R4336 VSS.n365 VSS.n337 4.5005
R4337 VSS.n366 VSS.n334 4.5005
R4338 VSS.n367 VSS.n331 4.5005
R4339 VSS.n368 VSS.n328 4.5005
R4340 VSS.n369 VSS.n325 4.5005
R4341 VSS.n370 VSS.n322 4.5005
R4342 VSS.n371 VSS.n319 4.5005
R4343 VSS.n372 VSS.n316 4.5005
R4344 VSS.n373 VSS.n313 4.5005
R4345 VSS.n374 VSS.n310 4.5005
R4346 VSS.n375 VSS.n307 4.5005
R4347 VSS.n376 VSS.n304 4.5005
R4348 VSS.n301 VSS.n377 4.5005
R4349 VSS.n298 VSS.n378 4.5005
R4350 VSS.n295 VSS.n379 4.5005
R4351 VSS.n292 VSS.n380 4.5005
R4352 VSS.n289 VSS.n381 4.5005
R4353 VSS.n286 VSS.n382 4.5005
R4354 VSS.n283 VSS.n383 4.5005
R4355 VSS.n280 VSS.n384 4.5005
R4356 VSS.n277 VSS.n385 4.5005
R4357 VSS.n274 VSS.n386 4.5005
R4358 VSS.n271 VSS.n387 4.5005
R4359 VSS.n268 VSS.n388 4.5005
R4360 VSS.n265 VSS.n389 4.5005
R4361 VSS.n262 VSS.n390 4.5005
R4362 VSS.n259 VSS.n391 4.5005
R4363 VSS.n256 VSS.n392 4.5005
R4364 VSS.n253 VSS.n393 4.5005
R4365 VSS.n250 VSS.n394 4.5005
R4366 VSS.n247 VSS.n395 4.5005
R4367 VSS.n244 VSS.n396 4.5005
R4368 VSS.n397 VSS.n241 4.5005
R4369 VSS.n398 VSS.n238 4.5005
R4370 VSS.n399 VSS.n235 4.5005
R4371 VSS.n400 VSS.n232 4.5005
R4372 VSS.n401 VSS.n229 4.5005
R4373 VSS.n402 VSS.n226 4.5005
R4374 VSS.n403 VSS.n223 4.5005
R4375 VSS.n404 VSS.n220 4.5005
R4376 VSS.n405 VSS.n217 4.5005
R4377 VSS.n406 VSS.n214 4.5005
R4378 VSS.n407 VSS.n211 4.5005
R4379 VSS.n408 VSS.n208 4.5005
R4380 VSS.n409 VSS.n205 4.5005
R4381 VSS.n410 VSS.n202 4.5005
R4382 VSS.n411 VSS.n199 4.5005
R4383 VSS.n412 VSS.n196 4.5005
R4384 VSS.n413 VSS.n193 4.5005
R4385 VSS.n414 VSS.n190 4.5005
R4386 VSS.n415 VSS.n187 4.5005
R4387 VSS.n416 VSS.n184 4.5005
R4388 VSS.n417 VSS.n181 4.5005
R4389 VSS.n418 VSS.n178 4.5005
R4390 VSS.n419 VSS.n175 4.5005
R4391 VSS.n420 VSS.n172 4.5005
R4392 VSS.n506 VSS.n169 4.5005
R4393 VSS.n357 VSS.n352 0.1445
R4394 VSS.n352 VSS.n349 0.1445
R4395 VSS.n349 VSS.n346 0.1445
R4396 VSS.n346 VSS.n343 0.1445
R4397 VSS.n343 VSS.n340 0.1445
R4398 VSS.n340 VSS.n337 0.1445
R4399 VSS.n337 VSS.n334 0.1445
R4400 VSS.n334 VSS.n331 0.1445
R4401 VSS.n331 VSS.n328 0.1445
R4402 VSS.n328 VSS.n325 0.1445
R4403 VSS.n325 VSS.n322 0.1445
R4404 VSS.n322 VSS.n319 0.1445
R4405 VSS.n319 VSS.n316 0.1445
R4406 VSS.n316 VSS.n313 0.1445
R4407 VSS.n313 VSS.n310 0.1445
R4408 VSS.n310 VSS.n307 0.1445
R4409 VSS.n307 VSS.n304 0.1445
R4410 VSS.n304 VSS.n301 0.1445
R4411 VSS.n301 VSS.n298 0.1445
R4412 VSS.n298 VSS.n295 0.1445
R4413 VSS.n295 VSS.n507 0.0545
R4414 VSS.n507 VSS.n292 0.0905
R4415 VSS.n292 VSS.n289 0.1445
R4416 VSS.n289 VSS.n286 0.1445
R4417 VSS.n286 VSS.n283 0.1445
R4418 VSS.n283 VSS.n280 0.1445
R4419 VSS.n280 VSS.n277 0.1445
R4420 VSS.n277 VSS.n274 0.1445
R4421 VSS.n274 VSS.n271 0.1445
R4422 VSS.n271 VSS.n268 0.1445
R4423 VSS.n268 VSS.n265 0.1445
R4424 VSS.n265 VSS.n262 0.1445
R4425 VSS.n262 VSS.n259 0.1445
R4426 VSS.n259 VSS.n256 0.1445
R4427 VSS.n253 VSS.n256 0.1445
R4428 VSS.n253 VSS.n250 0.1445
R4429 VSS.n250 VSS.n247 0.1445
R4430 VSS.n247 VSS.n244 0.1445
R4431 VSS.n244 VSS.n241 0.1445
R4432 VSS.n241 VSS.n238 0.1445
R4433 VSS.n238 VSS.n235 0.1445
R4434 VSS.n235 VSS.n232 0.1445
R4435 VSS.n232 VSS.n229 0.1445
R4436 VSS.n229 VSS.n508 0.0905
R4437 VSS.n226 VSS.n508 0.0545
R4438 VSS.n226 VSS.n223 0.1445
R4439 VSS.n223 VSS.n220 0.1445
R4440 VSS.n220 VSS.n217 0.1445
R4441 VSS.n217 VSS.n214 0.1445
R4442 VSS.n214 VSS.n211 0.1445
R4443 VSS.n211 VSS.n208 0.1445
R4444 VSS.n208 VSS.n205 0.1445
R4445 VSS.n205 VSS.n202 0.1445
R4446 VSS.n202 VSS.n199 0.1445
R4447 VSS.n199 VSS.n196 0.1445
R4448 VSS.n196 VSS.n193 0.1445
R4449 VSS.n193 VSS.n190 0.1445
R4450 VSS.n190 VSS.n187 0.1445
R4451 VSS.n187 VSS.n184 0.1445
R4452 VSS.n184 VSS.n181 0.1445
R4453 VSS.n181 VSS.n178 0.1445
R4454 VSS.n178 VSS.n175 0.1445
R4455 VSS.n175 VSS.n172 0.1445
R4456 VSS.n172 VSS.n169 0.1445
R4457 VSS.n169 VSS.n166 0.1445
R4458 VSS.n508 VSS.t26 19.1925
R4459 VSS.n507 VSS.t24 19.1925
R4460 VSS.n359 VSS.n360 0.1445
R4461 VSS.n360 VSS.n361 0.1445
R4462 VSS.n361 VSS.n505 0.1085
R4463 VSS.n505 VSS.n362 0.0365
R4464 VSS.n362 VSS.n363 0.1445
R4465 VSS.n363 VSS.n364 0.1445
R4466 VSS.n364 VSS.n365 0.1445
R4467 VSS.n365 VSS.n366 0.1445
R4468 VSS.n366 VSS.n367 0.1445
R4469 VSS.n367 VSS.n368 0.1445
R4470 VSS.n368 VSS.n369 0.1445
R4471 VSS.n369 VSS.n370 0.1445
R4472 VSS.n370 VSS.n371 0.1445
R4473 VSS.n371 VSS.n372 0.1445
R4474 VSS.n372 VSS.n373 0.1445
R4475 VSS.n373 VSS.n374 0.1445
R4476 VSS.n374 VSS.n375 0.1445
R4477 VSS.n375 VSS.n376 0.1445
R4478 VSS.n376 VSS.n377 0.1445
R4479 VSS.n377 VSS.n378 0.1445
R4480 VSS.n378 VSS.n379 0.1445
R4481 VSS.n379 VSS.n380 0.1445
R4482 VSS.n380 VSS.n381 0.1445
R4483 VSS.n381 VSS.n382 0.1445
R4484 VSS.n382 VSS.n383 0.1445
R4485 VSS.n383 VSS.n384 0.1445
R4486 VSS.n384 VSS.n385 0.1445
R4487 VSS.n385 VSS.n386 0.1445
R4488 VSS.n386 VSS.n387 0.1445
R4489 VSS.n388 VSS.n387 0.1445
R4490 VSS.n389 VSS.n388 0.1445
R4491 VSS.n390 VSS.n389 0.1445
R4492 VSS.n391 VSS.n390 0.1445
R4493 VSS.n392 VSS.n391 0.1445
R4494 VSS.n393 VSS.n392 0.1445
R4495 VSS.n394 VSS.n393 0.1445
R4496 VSS.n395 VSS.n394 0.1445
R4497 VSS.n396 VSS.n395 0.1445
R4498 VSS.n397 VSS.n396 0.1445
R4499 VSS.n398 VSS.n397 0.1445
R4500 VSS.n399 VSS.n398 0.1445
R4501 VSS.n400 VSS.n399 0.1445
R4502 VSS.n401 VSS.n400 0.1445
R4503 VSS.n402 VSS.n401 0.1445
R4504 VSS.n403 VSS.n402 0.1445
R4505 VSS.n404 VSS.n403 0.1445
R4506 VSS.n405 VSS.n404 0.1445
R4507 VSS.n406 VSS.n405 0.1445
R4508 VSS.n407 VSS.n406 0.1445
R4509 VSS.n408 VSS.n407 0.1445
R4510 VSS.n409 VSS.n408 0.1445
R4511 VSS.n410 VSS.n409 0.1445
R4512 VSS.n411 VSS.n410 0.1445
R4513 VSS.n412 VSS.n411 0.1445
R4514 VSS.n413 VSS.n412 0.1445
R4515 VSS.n414 VSS.n413 0.1445
R4516 VSS.n415 VSS.n414 0.1445
R4517 VSS.n416 VSS.n415 0.1445
R4518 VSS.n417 VSS.n416 0.1445
R4519 VSS.n418 VSS.n417 0.1445
R4520 VSS.n419 VSS.n418 0.1445
R4521 VSS.n420 VSS.n419 0.1445
R4522 VSS.n506 VSS.n420 0.1445
R4523 VSS.n358 VSS.n506 0.1445
R4524 VSS.n505 VSS.t108 32.3538
R4525 VSS.n502 VSS.n358 6.34773
R4526 VSS.n504 VSS.n503 0.348761
R4527 VSS.n502 VSS.n504 2.13702
R4528 VSS.n503 VSS.t30 1.93765
R4529 VSS.n504 VSS.t31 1.58939
R4530 VSS.n503 VSS.t28 21.2289
R4531 VSS.n499 VSS.n502 0.548326
R4532 VSS.n501 VSS.n500 0.348761
R4533 VSS.n499 VSS.n501 2.13702
R4534 VSS.n501 VSS.t38 1.58939
R4535 VSS.n500 VSS.t39 1.93765
R4536 VSS.n500 VSS.t37 21.2289
R4537 VSS.n163 VSS.n499 0.942565
R4538 VSS.n421 VSS.n163 8.01762
R4539 VSS.n10 VSS.n421 4.5005
R4540 VSS.n422 VSS.n28 4.5005
R4541 VSS.n26 VSS.n423 4.5005
R4542 VSS.n424 VSS.n24 4.5005
R4543 VSS.n22 VSS.n425 4.5005
R4544 VSS.n20 VSS.n426 4.5005
R4545 VSS.n18 VSS.n427 4.5005
R4546 VSS.n16 VSS.n428 4.5005
R4547 VSS.n14 VSS.n429 4.5005
R4548 VSS.n12 VSS.n430 4.5005
R4549 VSS.n422 VSS.n423 0.1445
R4550 VSS.n423 VSS.n424 0.1445
R4551 VSS.n424 VSS.n425 0.1445
R4552 VSS.n425 VSS.n426 0.1445
R4553 VSS.n426 VSS.n427 0.1445
R4554 VSS.n427 VSS.n428 0.1445
R4555 VSS.n428 VSS.n429 0.1445
R4556 VSS.n429 VSS.n430 0.1445
R4557 VSS.n430 VSS.n421 0.1445
R4558 VSS.n432 VSS.n32 4.5005
R4559 VSS.n433 VSS.n30 4.5005
R4560 VSS.n431 VSS.n432 0.04
R4561 VSS.n431 VSS.n433 0.041
R4562 VSS.n433 VSS.n422 0.1409
R4563 VSS.n434 VSS.n46 4.5005
R4564 VSS.n44 VSS.n435 4.5005
R4565 VSS.n436 VSS.n42 4.5005
R4566 VSS.n40 VSS.n437 4.5005
R4567 VSS.n38 VSS.n438 4.5005
R4568 VSS.n439 VSS.n36 4.5005
R4569 VSS.n440 VSS.n34 4.5005
R4570 VSS.n434 VSS.n435 0.1445
R4571 VSS.n435 VSS.n436 0.1445
R4572 VSS.n436 VSS.n437 0.1445
R4573 VSS.n437 VSS.n438 0.1445
R4574 VSS.n439 VSS.n438 0.1445
R4575 VSS.n440 VSS.n439 0.1445
R4576 VSS.n432 VSS.n440 0.1401
R4577 VSS.n442 VSS.n48 4.5005
R4578 VSS.n441 VSS.n442 0.008
R4579 VSS.n441 VSS.n434 0.095
R4580 VSS.n443 VSS.n62 4.5005
R4581 VSS.n60 VSS.n444 4.5005
R4582 VSS.n58 VSS.n445 4.5005
R4583 VSS.n56 VSS.n446 4.5005
R4584 VSS.n54 VSS.n447 4.5005
R4585 VSS.n52 VSS.n448 4.5005
R4586 VSS.n449 VSS.n50 4.5005
R4587 VSS.n443 VSS.n444 0.1445
R4588 VSS.n444 VSS.n445 0.1445
R4589 VSS.n445 VSS.n446 0.1445
R4590 VSS.n446 VSS.n447 0.1445
R4591 VSS.n448 VSS.n447 0.1445
R4592 VSS.n449 VSS.n448 0.1445
R4593 VSS.n442 VSS.n449 0.1145
R4594 VSS.n451 VSS.n64 4.5005
R4595 VSS.n450 VSS.n451 0.0245
R4596 VSS.n451 VSS.n443 0.1277
R4597 VSS.n452 VSS.n80 4.5005
R4598 VSS.n78 VSS.n453 4.5005
R4599 VSS.n76 VSS.n454 4.5005
R4600 VSS.n74 VSS.n455 4.5005
R4601 VSS.n72 VSS.n456 4.5005
R4602 VSS.n457 VSS.n70 4.5005
R4603 VSS.n68 VSS.n458 4.5005
R4604 VSS.n459 VSS.n66 4.5005
R4605 VSS.n452 VSS.n453 0.1445
R4606 VSS.n453 VSS.n454 0.1445
R4607 VSS.n454 VSS.n455 0.1445
R4608 VSS.n455 VSS.n456 0.1445
R4609 VSS.n457 VSS.n456 0.1445
R4610 VSS.n458 VSS.n457 0.1445
R4611 VSS.n459 VSS.n458 0.1445
R4612 VSS.n450 VSS.n459 0.0653
R4613 VSS.n461 VSS.n82 4.5005
R4614 VSS.n460 VSS.n461 0.0245
R4615 VSS.n460 VSS.n452 0.0653
R4616 VSS.n462 VSS.n96 4.5005
R4617 VSS.n463 VSS.n94 4.5005
R4618 VSS.n92 VSS.n464 4.5005
R4619 VSS.n90 VSS.n465 4.5005
R4620 VSS.n88 VSS.n466 4.5005
R4621 VSS.n467 VSS.n86 4.5005
R4622 VSS.n468 VSS.n84 4.5005
R4623 VSS.n462 VSS.n463 0.1445
R4624 VSS.n463 VSS.n464 0.1445
R4625 VSS.n464 VSS.n465 0.1445
R4626 VSS.n465 VSS.n466 0.1445
R4627 VSS.n467 VSS.n466 0.1445
R4628 VSS.n468 VSS.n467 0.1445
R4629 VSS.n461 VSS.n468 0.1277
R4630 VSS.n469 VSS.n98 4.5005
R4631 VSS.n470 VSS.n469 0.008
R4632 VSS.n469 VSS.n462 0.1145
R4633 VSS.n135 VSS.n471 4.5005
R4634 VSS.n472 VSS.n133 4.5005
R4635 VSS.n473 VSS.n131 4.5005
R4636 VSS.n474 VSS.n129 4.5005
R4637 VSS.n475 VSS.n127 4.5005
R4638 VSS.n476 VSS.n125 4.5005
R4639 VSS.n477 VSS.n123 4.5005
R4640 VSS.n121 VSS.n478 4.5005
R4641 VSS.n119 VSS.n479 4.5005
R4642 VSS.n117 VSS.n480 4.5005
R4643 VSS.n115 VSS.n481 4.5005
R4644 VSS.n113 VSS.n482 4.5005
R4645 VSS.n111 VSS.n483 4.5005
R4646 VSS.n109 VSS.n484 4.5005
R4647 VSS.n107 VSS.n485 4.5005
R4648 VSS.n486 VSS.n105 4.5005
R4649 VSS.n103 VSS.n487 4.5005
R4650 VSS.n101 VSS.n488 4.5005
R4651 VSS.n492 VSS.n489 4.5005
R4652 VSS.n472 VSS.n471 0.1445
R4653 VSS.n473 VSS.n472 0.1445
R4654 VSS.n474 VSS.n473 0.1445
R4655 VSS.n475 VSS.n474 0.1445
R4656 VSS.n476 VSS.n475 0.1445
R4657 VSS.n477 VSS.n476 0.1445
R4658 VSS.n478 VSS.n477 0.1445
R4659 VSS.n479 VSS.n478 0.1445
R4660 VSS.n480 VSS.n479 0.1445
R4661 VSS.n481 VSS.n480 0.1445
R4662 VSS.n482 VSS.n481 0.1445
R4663 VSS.n483 VSS.n482 0.1445
R4664 VSS.n484 VSS.n483 0.1445
R4665 VSS.n485 VSS.n484 0.1445
R4666 VSS.n486 VSS.n485 0.1445
R4667 VSS.n487 VSS.n486 0.1445
R4668 VSS.n488 VSS.n487 0.1445
R4669 VSS.n492 VSS.n488 0.1445
R4670 VSS.n470 VSS.n492 0.095
R4671 VSS.n471 VSS.n138 8.01762
R4672 VSS.n138 VSS.n496 0.942565
R4673 VSS.n496 VSS.n498 2.13702
R4674 VSS.n498 VSS.n497 0.348761
R4675 VSS.n497 VSS.t33 1.93765
R4676 VSS.n498 VSS.t34 1.58939
R4677 VSS.n497 VSS.t32 21.2289
R4678 VSS.n496 VSS.n493 0.548326
R4679 VSS.n493 VSS.n495 2.13702
R4680 VSS.n495 VSS.n494 0.348761
R4681 VSS.n495 VSS.t22 1.58939
R4682 VSS.n494 VSS.t23 1.93765
R4683 VSS.n494 VSS.t20 21.2289
R4684 VSS.n493 VSS.n359 6.34773
R4685 VSS.n133 VSS.n135 0.1445
R4686 VSS.n133 VSS.n131 0.1445
R4687 VSS.n131 VSS.n129 0.1445
R4688 VSS.n129 VSS.n127 0.1445
R4689 VSS.n127 VSS.n125 0.1445
R4690 VSS.n125 VSS.n123 0.1445
R4691 VSS.n123 VSS.n121 0.1445
R4692 VSS.n119 VSS.n121 0.1445
R4693 VSS.n117 VSS.n119 0.1445
R4694 VSS.n115 VSS.n117 0.1445
R4695 VSS.n113 VSS.n115 0.1445
R4696 VSS.n111 VSS.n113 0.1445
R4697 VSS.n109 VSS.n111 0.1445
R4698 VSS.n107 VSS.n109 0.1445
R4699 VSS.n105 VSS.n107 0.1445
R4700 VSS.n105 VSS.n103 0.1445
R4701 VSS.n101 VSS.n103 0.1445
R4702 VSS.n489 VSS.n101 0.1445
R4703 VSS.n489 VSS.n98 0.1445
R4704 VSS.n98 VSS.n96 0.1445
R4705 VSS.n96 VSS.n94 0.1445
R4706 VSS.n94 VSS.n92 0.1445
R4707 VSS.n92 VSS.n90 0.1445
R4708 VSS.n90 VSS.n88 0.1445
R4709 VSS.n491 VSS.n88 0.1409
R4710 VSS.n86 VSS.n491 0.0041
R4711 VSS.n86 VSS.n84 0.1445
R4712 VSS.n84 VSS.n82 0.1445
R4713 VSS.n82 VSS.n80 0.1445
R4714 VSS.n80 VSS.n78 0.1445
R4715 VSS.n78 VSS.n76 0.1445
R4716 VSS.n76 VSS.n74 0.1445
R4717 VSS.n74 VSS.n72 0.1445
R4718 VSS.n70 VSS.n72 0.1445
R4719 VSS.n70 VSS.n68 0.1445
R4720 VSS.n66 VSS.n68 0.1445
R4721 VSS.n66 VSS.n64 0.1445
R4722 VSS.n64 VSS.n62 0.1445
R4723 VSS.n62 VSS.n60 0.1445
R4724 VSS.n60 VSS.n490 0.0041
R4725 VSS.n490 VSS.n58 0.1409
R4726 VSS.n58 VSS.n56 0.1445
R4727 VSS.n56 VSS.n54 0.1445
R4728 VSS.n52 VSS.n54 0.1445
R4729 VSS.n50 VSS.n52 0.1445
R4730 VSS.n50 VSS.n48 0.1445
R4731 VSS.n48 VSS.n46 0.1445
R4732 VSS.n46 VSS.n44 0.1445
R4733 VSS.n44 VSS.n42 0.1445
R4734 VSS.n42 VSS.n40 0.1445
R4735 VSS.n40 VSS.n38 0.1445
R4736 VSS.n36 VSS.n38 0.1445
R4737 VSS.n36 VSS.n34 0.1445
R4738 VSS.n34 VSS.n32 0.1445
R4739 VSS.n32 VSS.n30 0.1445
R4740 VSS.n30 VSS.n28 0.1445
R4741 VSS.n28 VSS.n26 0.1445
R4742 VSS.n26 VSS.n24 0.1445
R4743 VSS.n24 VSS.n22 0.1445
R4744 VSS.n22 VSS.n20 0.1445
R4745 VSS.n20 VSS.n18 0.1445
R4746 VSS.n18 VSS.n16 0.1445
R4747 VSS.n16 VSS.n14 0.1445
R4748 VSS.n14 VSS.n12 0.1445
R4749 VSS.n12 VSS.n10 0.1445
R4750 VSS.n491 VSS.t44 72.7258
R4751 VSS.n490 VSS.t48 72.7258
R4752 VSS.n3 VSS.n470 7.39535
R4753 VSS.n4 VSS.n460 7.39535
R4754 VSS.n5 VSS.n450 7.39535
R4755 VSS.n6 VSS.n441 7.39535
R4756 VSS.n7 VSS.n431 7.39535
R4757 VSS.n356 VSS.n351 15.5561
R4758 VSS.n351 VSS.n348 15.5561
R4759 VSS.n348 VSS.n345 15.5561
R4760 VSS.n345 VSS.n342 15.5561
R4761 VSS.n342 VSS.n339 15.5561
R4762 VSS.n339 VSS.n336 15.5561
R4763 VSS.n336 VSS.n333 15.5561
R4764 VSS.n333 VSS.n330 15.5561
R4765 VSS.n330 VSS.n327 15.5561
R4766 VSS.n327 VSS.n324 15.5561
R4767 VSS.n324 VSS.n321 15.5561
R4768 VSS.n321 VSS.n318 15.5561
R4769 VSS.n318 VSS.n315 15.5561
R4770 VSS.n315 VSS.n312 15.5561
R4771 VSS.n312 VSS.n309 15.5561
R4772 VSS.n309 VSS.n306 15.5561
R4773 VSS.n306 VSS.n303 15.5561
R4774 VSS.n303 VSS.n300 15.5561
R4775 VSS.n300 VSS.n297 15.5561
R4776 VSS.n297 VSS.n294 15.5561
R4777 VSS.n294 VSS.n291 15.5561
R4778 VSS.n291 VSS.n288 15.5561
R4779 VSS.n288 VSS.n285 15.5561
R4780 VSS.n285 VSS.n282 15.5561
R4781 VSS.n282 VSS.n279 15.5561
R4782 VSS.n279 VSS.n276 15.5561
R4783 VSS.n276 VSS.n273 15.5561
R4784 VSS.n273 VSS.n270 15.5561
R4785 VSS.n270 VSS.n267 15.5561
R4786 VSS.n267 VSS.n264 15.5561
R4787 VSS.n264 VSS.n261 15.5561
R4788 VSS.n261 VSS.n258 15.5561
R4789 VSS.n258 VSS.n255 15.5561
R4790 VSS.n255 VSS.n252 15.5561
R4791 VSS.n252 VSS.n249 15.5561
R4792 VSS.n249 VSS.n246 15.5561
R4793 VSS.n246 VSS.n243 15.5561
R4794 VSS.n243 VSS.n240 15.5561
R4795 VSS.n240 VSS.n237 15.5561
R4796 VSS.n237 VSS.n234 15.5561
R4797 VSS.n234 VSS.n231 15.5561
R4798 VSS.n231 VSS.n228 15.5561
R4799 VSS.n228 VSS.n225 15.5561
R4800 VSS.n225 VSS.n222 15.5561
R4801 VSS.n222 VSS.n219 15.5561
R4802 VSS.n219 VSS.n216 15.5561
R4803 VSS.n216 VSS.n213 15.5561
R4804 VSS.n213 VSS.n210 15.5561
R4805 VSS.n210 VSS.n207 15.5561
R4806 VSS.n207 VSS.n204 15.5561
R4807 VSS.n204 VSS.n201 15.5561
R4808 VSS.n201 VSS.n198 15.5561
R4809 VSS.n198 VSS.n195 15.5561
R4810 VSS.n195 VSS.n192 15.5561
R4811 VSS.n192 VSS.n189 15.5561
R4812 VSS.n189 VSS.n186 15.5561
R4813 VSS.n186 VSS.n183 15.5561
R4814 VSS.n183 VSS.n180 15.5561
R4815 VSS.n180 VSS.n177 15.5561
R4816 VSS.n177 VSS.n174 15.5561
R4817 VSS.n174 VSS.n171 15.5561
R4818 VSS.n171 VSS.n168 15.5561
R4819 VSS.n168 VSS.n165 15.5561
R4820 VSS.n162 VSS.n354 61.3477
R4821 VSS.n162 VSS.n165 349.029
R4822 VSS.n355 VSS.n140 405.392
R4823 VSS.n140 VSS.n354 405.392
R4824 VSS.n137 VSS.n355 61.3477
R4825 VSS.n137 VSS.n356 349.029
R4826 VSS.n355 VSS.n134 278.736
R4827 VSS.n134 VSS.n132 15.5561
R4828 VSS.n132 VSS.n130 15.5561
R4829 VSS.n130 VSS.n128 15.5561
R4830 VSS.n128 VSS.n126 15.5561
R4831 VSS.n126 VSS.n124 15.5561
R4832 VSS.n124 VSS.n122 15.5561
R4833 VSS.n122 VSS.n120 15.5561
R4834 VSS.n120 VSS.n118 15.5561
R4835 VSS.n118 VSS.n116 15.5561
R4836 VSS.n116 VSS.n114 15.5561
R4837 VSS.n114 VSS.n112 15.5561
R4838 VSS.n112 VSS.n110 15.5561
R4839 VSS.n110 VSS.n108 15.5561
R4840 VSS.n108 VSS.n106 15.5561
R4841 VSS.n106 VSS.n104 15.5561
R4842 VSS.n104 VSS.n102 15.5561
R4843 VSS.n102 VSS.n100 15.5561
R4844 VSS.n100 VSS.n99 15.5561
R4845 VSS.n99 VSS.n97 15.5561
R4846 VSS.n97 VSS.n95 15.5561
R4847 VSS.n95 VSS.n93 15.5561
R4848 VSS.n93 VSS.n91 15.5561
R4849 VSS.n91 VSS.n89 15.5561
R4850 VSS.n89 VSS.n87 15.5561
R4851 VSS.n87 VSS.n85 15.5561
R4852 VSS.n85 VSS.n83 15.5561
R4853 VSS.n83 VSS.n81 15.5561
R4854 VSS.n81 VSS.n79 15.5561
R4855 VSS.n79 VSS.n77 15.5561
R4856 VSS.n77 VSS.n75 15.5561
R4857 VSS.n75 VSS.n73 15.5561
R4858 VSS.n73 VSS.n71 15.5561
R4859 VSS.n71 VSS.n69 15.5561
R4860 VSS.n69 VSS.n67 15.5561
R4861 VSS.n67 VSS.n65 15.5561
R4862 VSS.n65 VSS.n63 15.5561
R4863 VSS.n63 VSS.n61 15.5561
R4864 VSS.n61 VSS.n59 15.5561
R4865 VSS.n59 VSS.n57 15.5561
R4866 VSS.n57 VSS.n55 15.5561
R4867 VSS.n55 VSS.n53 15.5561
R4868 VSS.n53 VSS.n51 15.5561
R4869 VSS.n51 VSS.n49 15.5561
R4870 VSS.n49 VSS.n47 15.5561
R4871 VSS.n47 VSS.n45 15.5561
R4872 VSS.n45 VSS.n43 15.5561
R4873 VSS.n43 VSS.n41 15.5561
R4874 VSS.n41 VSS.n39 15.5561
R4875 VSS.n39 VSS.n37 15.5561
R4876 VSS.n37 VSS.n35 15.5561
R4877 VSS.n35 VSS.n33 15.5561
R4878 VSS.n33 VSS.n31 15.5561
R4879 VSS.n31 VSS.n29 15.5561
R4880 VSS.n29 VSS.n27 15.5561
R4881 VSS.n27 VSS.n25 15.5561
R4882 VSS.n25 VSS.n23 15.5561
R4883 VSS.n23 VSS.n21 15.5561
R4884 VSS.n21 VSS.n19 15.5561
R4885 VSS.n19 VSS.n17 15.5561
R4886 VSS.n17 VSS.n15 15.5561
R4887 VSS.n15 VSS.n13 15.5561
R4888 VSS.n13 VSS.n11 15.5561
R4889 VSS.n11 VSS.n9 15.5561
R4890 VSS.n9 VSS.n354 278.736
R4891 VSS.n144 VSS.n145 0.237239
R4892 VSS.n147 VSS.n144 0.203978
R4893 VSS.n148 VSS.n147 0.403543
R4894 VSS.n150 VSS.n148 0.227457
R4895 VSS.n152 VSS.n150 0.454413
R4896 VSS.n142 VSS.n152 0.454413
R4897 VSS.n142 VSS.n154 0.454413
R4898 VSS.n154 VSS.n156 0.454413
R4899 VSS.n156 VSS.n157 0.227457
R4900 VSS.n157 VSS.n159 0.403543
R4901 VSS.n159 VSS.n143 0.203978
R4902 VSS.n143 VSS.n160 1.32507
R4903 VSS.n160 VSS.t105 2.92191
R4904 VSS.n160 VSS.t99 2.3643
R4905 VSS.n159 VSS.n158 1.09126
R4906 VSS.n158 VSS.t54 7.99442
R4907 VSS.n158 VSS.t55 7.99442
R4908 VSS.n158 VSS.t52 22.619
R4909 VSS.n157 VSS.t50 9.05779
R4910 VSS.n156 VSS.n155 7.64659
R4911 VSS.n155 VSS.t75 1.4117
R4912 VSS.n155 VSS.t51 1.4117
R4913 VSS.n154 VSS.n153 7.64659
R4914 VSS.n153 VSS.t1 1.4117
R4915 VSS.n153 VSS.t8 1.4117
R4916 VSS.n152 VSS.n151 7.64659
R4917 VSS.n151 VSS.t6 1.4117
R4918 VSS.n151 VSS.t67 1.4117
R4919 VSS.n150 VSS.n149 7.64659
R4920 VSS.n149 VSS.t46 1.4117
R4921 VSS.n149 VSS.t81 1.4117
R4922 VSS.n148 VSS.t47 9.05779
R4923 VSS.n147 VSS.n146 1.09126
R4924 VSS.n146 VSS.t42 7.99442
R4925 VSS.n146 VSS.t43 7.99442
R4926 VSS.n146 VSS.t40 22.619
R4927 VSS.n145 VSS.t101 9.41059
R4928 VSS.n145 VSS.t64 11.7322
R4929 VSS.n144 VSS.t35 19.2052
R4930 VSS.n143 VSS.t36 19.2052
R4931 VSS.n142 VSS.n141 7.64659
R4932 VSS.n141 VSS.t92 1.4117
R4933 VSS.n141 VSS.t83 1.4117
R4934 VSS.n2 VSS.t96 19.576
R4935 IREF.n0 IREF.t5 1.4117
R4936 IREF.n0 IREF.t7 1.4117
R4937 IREF.n3 IREF.n0 12.9455
R4938 IREF.n11 IREF.n1 8.1221
R4939 IREF.n1 IREF.n3 1.4027
R4940 IREF IREF.n11 0.5261
R4941 IREF IREF.t9 27.6666
R4942 IREF.n11 IREF.n4 12.7022
R4943 IREF.n4 IREF.n5 0.227457
R4944 IREF.n5 IREF.n6 0.227457
R4945 IREF.n6 IREF.n7 0.227457
R4946 IREF.n7 IREF.n8 0.227457
R4947 IREF.n8 IREF.n9 0.227457
R4948 IREF.n9 IREF.n10 0.227457
R4949 IREF.n10 IREF.t6 54.3391
R4950 IREF.n10 IREF.t4 54.1122
R4951 IREF.n9 IREF.t10 54.1122
R4952 IREF.n8 IREF.t11 54.1122
R4953 IREF.n7 IREF.t12 54.1122
R4954 IREF.n6 IREF.t13 54.1122
R4955 IREF.n5 IREF.t2 54.1122
R4956 IREF.n4 IREF.t0 54.1122
R4957 IREF.n3 IREF.n2 11.6927
R4958 IREF.n2 IREF.t1 1.4117
R4959 IREF.n2 IREF.t3 1.4117
R4960 IREF.n1 IREF.t8 13.4567
R4961 a_23576_3894.t10 a_23576_3894.n0 1.4117
R4962 a_23576_3894.n0 a_23576_3894.t11 1.4117
R4963 a_23576_3894.n0 a_23576_3894.n2 12.2668
R4964 a_23576_3894.n2 a_23576_3894.n4 17.9771
R4965 a_23576_3894.n4 a_23576_3894.n6 1.2821
R4966 a_23576_3894.n6 a_23576_3894.n8 6.05659
R4967 a_23576_3894.n8 a_23576_3894.t2 0.3533
R4968 a_23576_3894.n8 a_23576_3894.t5 0.3533
R4969 a_23576_3894.n6 a_23576_3894.n7 11.115
R4970 a_23576_3894.n7 a_23576_3894.t6 0.3533
R4971 a_23576_3894.n7 a_23576_3894.t1 0.3533
R4972 a_23576_3894.n4 a_23576_3894.n5 11.115
R4973 a_23576_3894.n5 a_23576_3894.t3 0.3533
R4974 a_23576_3894.n5 a_23576_3894.t7 0.3533
R4975 a_23576_3894.n4 a_23576_3894.n3 6.05659
R4976 a_23576_3894.n3 a_23576_3894.t4 0.3533
R4977 a_23576_3894.n3 a_23576_3894.t0 0.3533
R4978 a_23576_3894.n2 a_23576_3894.n1 11.8492
R4979 a_23576_3894.n1 a_23576_3894.t8 1.4117
R4980 a_23576_3894.n1 a_23576_3894.t9 1.4117
R4981 a_22144_9605.n0 a_22144_9605.t5 1.5685
R4982 a_22144_9605.t2 a_22144_9605.n0 1.5685
R4983 a_22144_9605.n0 a_22144_9605.n11 10.7492
R4984 a_22144_9605.n2 a_22144_9605.n10 14.4779
R4985 a_22144_9605.n11 a_22144_9605.n2 0.4001
R4986 a_22144_9605.n10 a_22144_9605.n8 0.6413
R4987 a_22144_9605.n8 a_22144_9605.n5 1.2821
R4988 a_22144_9605.n5 a_22144_9605.n6 1.2821
R4989 a_22144_9605.n6 a_22144_9605.t11 13.5823
R4990 a_22144_9605.n10 a_22144_9605.t8 12.9415
R4991 a_22144_9605.n8 a_22144_9605.n9 12.1575
R4992 a_22144_9605.n9 a_22144_9605.t9 0.7845
R4993 a_22144_9605.n9 a_22144_9605.t1 0.7845
R4994 a_22144_9605.n6 a_22144_9605.n7 12.1575
R4995 a_22144_9605.n7 a_22144_9605.t0 0.7845
R4996 a_22144_9605.n7 a_22144_9605.t10 0.7845
R4997 a_22144_9605.n5 a_22144_9605.n4 6.59881
R4998 a_22144_9605.n4 a_22144_9605.t3 0.7845
R4999 a_22144_9605.n4 a_22144_9605.t6 0.7845
R5000 a_22144_9605.n11 a_22144_9605.n3 11.1488
R5001 a_22144_9605.n3 a_22144_9605.t4 1.5685
R5002 a_22144_9605.n3 a_22144_9605.t12 1.5685
R5003 a_22144_9605.n2 a_22144_9605.n1 10.7492
R5004 a_22144_9605.n1 a_22144_9605.t7 1.5685
R5005 a_22144_9605.n1 a_22144_9605.t13 1.5685
R5006 a_22144_8265.n0 a_22144_8265.t9 1.5685
R5007 a_22144_8265.t0 a_22144_8265.n0 1.5685
R5008 a_22144_8265.n0 a_22144_8265.n17 10.5927
R5009 a_22144_8265.n17 a_22144_8265.n5 7.8773
R5010 a_22144_8265.n5 a_22144_8265.n16 1.0679
R5011 a_22144_8265.n16 a_22144_8265.n9 5.8541
R5012 a_22144_8265.n9 a_22144_8265.n11 0.6413
R5013 a_22144_8265.n11 a_22144_8265.n14 1.2821
R5014 a_22144_8265.n14 a_22144_8265.n13 1.2821
R5015 a_22144_8265.n14 a_22144_8265.n15 12.4455
R5016 a_22144_8265.n15 a_22144_8265.t2 0.7845
R5017 a_22144_8265.n15 a_22144_8265.t4 0.7845
R5018 a_22144_8265.n13 a_22144_8265.t13 7.71057
R5019 a_22144_8265.n13 a_22144_8265.n12 6.28577
R5020 a_22144_8265.n12 a_22144_8265.t8 0.7845
R5021 a_22144_8265.n12 a_22144_8265.t14 0.7845
R5022 a_22144_8265.n11 a_22144_8265.n10 6.28577
R5023 a_22144_8265.n10 a_22144_8265.t11 0.7845
R5024 a_22144_8265.n10 a_22144_8265.t6 0.7845
R5025 a_22144_8265.n9 a_22144_8265.t12 7.06977
R5026 a_22144_8265.n16 a_22144_8265.n6 12.2921
R5027 a_22144_8265.n6 a_22144_8265.n7 0.697022
R5028 a_22144_8265.n7 a_22144_8265.n8 0.697022
R5029 a_22144_8265.n8 a_22144_8265.t7 13.0284
R5030 a_22144_8265.n8 a_22144_8265.t16 12.3318
R5031 a_22144_8265.n7 a_22144_8265.t17 12.3318
R5032 a_22144_8265.n6 a_22144_8265.t5 12.3318
R5033 a_22144_8265.n5 a_22144_8265.n2 11.5127
R5034 a_22144_8265.n2 a_22144_8265.n3 0.697022
R5035 a_22144_8265.n3 a_22144_8265.n4 0.697022
R5036 a_22144_8265.n4 a_22144_8265.t18 13.0284
R5037 a_22144_8265.n4 a_22144_8265.t3 12.3318
R5038 a_22144_8265.n3 a_22144_8265.t1 12.3318
R5039 a_22144_8265.n2 a_22144_8265.t19 12.3318
R5040 a_22144_8265.n17 a_22144_8265.n1 12.1911
R5041 a_22144_8265.n1 a_22144_8265.t15 1.5685
R5042 a_22144_8265.n1 a_22144_8265.t10 1.5685
R5043 v2_pmos_core.EN_5V v2_pmos_core.EN_5V.t0 21.2754
R5044 v2_pmos_core.EN_5V v2_pmos_core.EN_5V.n0 2.8481
R5045 v2_pmos_core.EN_5V.n0 v2_pmos_core.EN_5V.t1 17.6311
R5046 v2_pmos_core.EN_5V.n0 v2_pmos_core.EN_5V.t2 72.6347
R5047 v2_pmos_core.EAREF.n0 v2_pmos_core.EAREF.t21 1.5685
R5048 v2_pmos_core.EAREF.n0 v2_pmos_core.EAREF.t12 1.5685
R5049 v2_pmos_core.EAREF.n23 v2_pmos_core.EAREF.n0 10.4362
R5050 v2_pmos_core.EAREF.n22 v2_pmos_core.EAREF.n1 6.7217
R5051 v2_pmos_core.EAREF.n1 v2_pmos_core.EAREF.n3 0.2003
R5052 v2_pmos_core.EAREF.n3 v2_pmos_core.EAREF.n5 0.4001
R5053 v2_pmos_core.EAREF.n5 v2_pmos_core.EAREF.n7 1.1993
R5054 v2_pmos_core.EAREF.n7 v2_pmos_core.EAREF.n23 0.4001
R5055 v2_pmos_core.EAREF v2_pmos_core.EAREF.n22 3.2801
R5056 v2_pmos_core.EAREF v2_pmos_core.EAREF.n15 8.0411
R5057 v2_pmos_core.EAREF.n15 v2_pmos_core.EAREF.n17 0.6413
R5058 v2_pmos_core.EAREF.n17 v2_pmos_core.EAREF.n20 1.2821
R5059 v2_pmos_core.EAREF.n20 v2_pmos_core.EAREF.n19 1.2821
R5060 v2_pmos_core.EAREF.n20 v2_pmos_core.EAREF.n21 11.259
R5061 v2_pmos_core.EAREF.t4 v2_pmos_core.EAREF.n21 0.3533
R5062 v2_pmos_core.EAREF.n21 v2_pmos_core.EAREF.t5 0.3533
R5063 v2_pmos_core.EAREF.t2 v2_pmos_core.EAREF.n19 6.89367
R5064 v2_pmos_core.EAREF.n18 v2_pmos_core.EAREF.n19 5.90007
R5065 v2_pmos_core.EAREF.t7 v2_pmos_core.EAREF.n18 0.3533
R5066 v2_pmos_core.EAREF.n18 v2_pmos_core.EAREF.t3 0.3533
R5067 v2_pmos_core.EAREF.n16 v2_pmos_core.EAREF.n17 5.90007
R5068 v2_pmos_core.EAREF.t0 v2_pmos_core.EAREF.n16 0.3533
R5069 v2_pmos_core.EAREF.n16 v2_pmos_core.EAREF.t6 0.3533
R5070 v2_pmos_core.EAREF.n15 v2_pmos_core.EAREF.t1 6.25287
R5071 v2_pmos_core.EAREF.n22 v2_pmos_core.EAREF.n8 12.9661
R5072 v2_pmos_core.EAREF.n8 v2_pmos_core.EAREF.n9 0.217674
R5073 v2_pmos_core.EAREF.n9 v2_pmos_core.EAREF.n10 0.434848
R5074 v2_pmos_core.EAREF.n10 v2_pmos_core.EAREF.n11 0.217674
R5075 v2_pmos_core.EAREF.n11 v2_pmos_core.EAREF.n12 0.217674
R5076 v2_pmos_core.EAREF.n12 v2_pmos_core.EAREF.n13 0.217674
R5077 v2_pmos_core.EAREF.n13 v2_pmos_core.EAREF.n14 0.434848
R5078 v2_pmos_core.EAREF.n14 v2_pmos_core.EAREF.t20 48.434
R5079 v2_pmos_core.EAREF.n14 v2_pmos_core.EAREF.t18 48.2169
R5080 v2_pmos_core.EAREF.n13 v2_pmos_core.EAREF.t22 48.2169
R5081 v2_pmos_core.EAREF.n12 v2_pmos_core.EAREF.t23 48.2169
R5082 v2_pmos_core.EAREF.n11 v2_pmos_core.EAREF.t24 48.2169
R5083 v2_pmos_core.EAREF.n10 v2_pmos_core.EAREF.t25 48.2169
R5084 v2_pmos_core.EAREF.n9 v2_pmos_core.EAREF.t16 48.2169
R5085 v2_pmos_core.EAREF.n8 v2_pmos_core.EAREF.t14 48.2169
R5086 v2_pmos_core.EAREF.n23 v2_pmos_core.EAREF.t13 12.204
R5087 v2_pmos_core.EAREF.n7 v2_pmos_core.EAREF.n6 10.4362
R5088 v2_pmos_core.EAREF.n6 v2_pmos_core.EAREF.t9 1.5685
R5089 v2_pmos_core.EAREF.n6 v2_pmos_core.EAREF.t19 1.5685
R5090 v2_pmos_core.EAREF.n5 v2_pmos_core.EAREF.n4 10.4362
R5091 v2_pmos_core.EAREF.n4 v2_pmos_core.EAREF.t17 1.5685
R5092 v2_pmos_core.EAREF.n4 v2_pmos_core.EAREF.t8 1.5685
R5093 v2_pmos_core.EAREF.n3 v2_pmos_core.EAREF.n2 10.4362
R5094 v2_pmos_core.EAREF.n2 v2_pmos_core.EAREF.t10 1.5685
R5095 v2_pmos_core.EAREF.n2 v2_pmos_core.EAREF.t15 1.5685
R5096 v2_pmos_core.EAREF.n1 v2_pmos_core.EAREF.t11 12.0042
R5097 EAOUT.n645 EAOUT.t0 6.79497
R5098 EAOUT.n645 EAOUT.n2 3.2423
R5099 EAOUT.n644 EAOUT.n645 5.1989
R5100 EAOUT EAOUT.n644 2.7041
R5101 EAOUT EAOUT.n644 3.3089
R5102 EAOUT EAOUT.n642 0.506868
R5103 EAOUT.n642 EAOUT.n643 0.166289
R5104 EAOUT.n643 EAOUT.n641 5.31761
R5105 EAOUT.n643 EAOUT.t14 117.853
R5106 EAOUT.n642 EAOUT 5.83155
R5107 EAOUT EAOUT.t13 6.11018
R5108 EAOUT.n10 EAOUT.n152 12.5005
R5109 EAOUT.n11 EAOUT.n153 12.5005
R5110 EAOUT.n12 EAOUT.n151 12.5005
R5111 EAOUT.n13 EAOUT.n150 12.5005
R5112 EAOUT.n14 EAOUT.n155 12.5005
R5113 EAOUT.n15 EAOUT.n156 12.5005
R5114 EAOUT.n16 EAOUT.n149 12.5005
R5115 EAOUT.n17 EAOUT.n148 12.5005
R5116 EAOUT.n18 EAOUT.n158 12.5005
R5117 EAOUT.n19 EAOUT.n147 12.5005
R5118 EAOUT.n20 EAOUT.n146 12.5005
R5119 EAOUT.n21 EAOUT.n159 12.5005
R5120 EAOUT.n22 EAOUT.n160 12.5005
R5121 EAOUT.n23 EAOUT.n145 12.5005
R5122 EAOUT.n24 EAOUT.n144 12.5005
R5123 EAOUT.n25 EAOUT.n162 12.5005
R5124 EAOUT.n26 EAOUT.n163 12.5005
R5125 EAOUT.n27 EAOUT.n143 12.5005
R5126 EAOUT.n28 EAOUT.n164 12.5005
R5127 EAOUT.n29 EAOUT.n165 12.5005
R5128 EAOUT.n30 EAOUT.n142 12.5005
R5129 EAOUT.n31 EAOUT.n141 12.5005
R5130 EAOUT.n32 EAOUT.n167 12.5005
R5131 EAOUT.n33 EAOUT.n168 12.5005
R5132 EAOUT.n34 EAOUT.n140 12.5005
R5133 EAOUT.n35 EAOUT.n139 12.5005
R5134 EAOUT.n36 EAOUT.n170 12.5005
R5135 EAOUT.n37 EAOUT.n138 12.5005
R5136 EAOUT.n38 EAOUT.n137 12.5005
R5137 EAOUT.n39 EAOUT.n172 12.5005
R5138 EAOUT.n40 EAOUT.n173 12.5005
R5139 EAOUT.n41 EAOUT.n136 12.5005
R5140 EAOUT.n42 EAOUT.n135 12.5005
R5141 EAOUT.n43 EAOUT.n175 12.5005
R5142 EAOUT.n44 EAOUT.n176 12.5005
R5143 EAOUT.n45 EAOUT.n134 12.5005
R5144 EAOUT.n46 EAOUT.n177 12.5005
R5145 EAOUT.n47 EAOUT.n178 12.5005
R5146 EAOUT.n48 EAOUT.n133 12.5005
R5147 EAOUT.n49 EAOUT.n132 12.5005
R5148 EAOUT.n50 EAOUT.n180 12.5005
R5149 EAOUT.n51 EAOUT.n181 12.5005
R5150 EAOUT.n52 EAOUT.n131 12.5005
R5151 EAOUT.n53 EAOUT.n130 12.5005
R5152 EAOUT.n54 EAOUT.n183 12.5005
R5153 EAOUT.n55 EAOUT.n129 12.5005
R5154 EAOUT.n56 EAOUT.n128 12.5005
R5155 EAOUT.n57 EAOUT.n185 12.5005
R5156 EAOUT.n58 EAOUT.n186 12.5005
R5157 EAOUT.n59 EAOUT.n127 12.5005
R5158 EAOUT.n60 EAOUT.n126 12.5005
R5159 EAOUT.n61 EAOUT.n188 12.5005
R5160 EAOUT.n62 EAOUT.n125 12.5005
R5161 EAOUT.n63 EAOUT.n124 12.5005
R5162 EAOUT.n64 EAOUT.n190 12.5005
R5163 EAOUT.n65 EAOUT.n191 12.5005
R5164 EAOUT.n66 EAOUT.n123 12.5005
R5165 EAOUT.n67 EAOUT.n122 12.5005
R5166 EAOUT.n68 EAOUT.n193 12.5005
R5167 EAOUT.n69 EAOUT.n194 12.5005
R5168 EAOUT.n70 EAOUT.n121 12.5005
R5169 EAOUT.n71 EAOUT.n195 12.5005
R5170 EAOUT.n72 EAOUT.n196 12.5005
R5171 EAOUT.n73 EAOUT.n120 12.5005
R5172 EAOUT.n74 EAOUT.n119 12.5005
R5173 EAOUT.n75 EAOUT.n198 12.5005
R5174 EAOUT.n76 EAOUT.n199 12.5005
R5175 EAOUT.n77 EAOUT.n118 12.5005
R5176 EAOUT.n78 EAOUT.n117 12.5005
R5177 EAOUT.n79 EAOUT.n201 12.5005
R5178 EAOUT.n80 EAOUT.n116 12.5005
R5179 EAOUT.n81 EAOUT.n115 12.5005
R5180 EAOUT.n82 EAOUT.n203 12.5005
R5181 EAOUT.n83 EAOUT.n204 12.5005
R5182 EAOUT.n84 EAOUT.n114 12.5005
R5183 EAOUT.n85 EAOUT.n113 12.5005
R5184 EAOUT.n86 EAOUT.n206 12.5005
R5185 EAOUT.n87 EAOUT.n207 12.5005
R5186 EAOUT.n88 EAOUT.n112 12.5005
R5187 EAOUT.n89 EAOUT.n208 12.5005
R5188 EAOUT.n90 EAOUT.n209 12.5005
R5189 EAOUT.n91 EAOUT.n111 12.5005
R5190 EAOUT.n92 EAOUT.n110 12.5005
R5191 EAOUT.n93 EAOUT.n211 12.5005
R5192 EAOUT.n94 EAOUT.n212 12.5005
R5193 EAOUT.n95 EAOUT.n109 12.5005
R5194 EAOUT.n96 EAOUT.n213 12.5005
R5195 EAOUT.n97 EAOUT.n214 12.5005
R5196 EAOUT.n98 EAOUT.n108 12.5005
R5197 EAOUT.n99 EAOUT.n107 12.5005
R5198 EAOUT.n100 EAOUT.n216 12.5005
R5199 EAOUT.n101 EAOUT.n217 12.5005
R5200 EAOUT.n102 EAOUT.n106 12.5005
R5201 EAOUT.n103 EAOUT.n105 12.5005
R5202 EAOUT.n104 EAOUT.n219 2.98483
R5203 EAOUT.n103 EAOUT.n104 4.93033
R5204 EAOUT.n102 EAOUT.n103 0.1445
R5205 EAOUT.n101 EAOUT.n102 0.1445
R5206 EAOUT.n100 EAOUT.n101 0.1445
R5207 EAOUT.n99 EAOUT.n100 0.1445
R5208 EAOUT.n98 EAOUT.n99 0.1445
R5209 EAOUT.n97 EAOUT.n98 0.1445
R5210 EAOUT.n96 EAOUT.n97 0.1445
R5211 EAOUT.n95 EAOUT.n96 0.1445
R5212 EAOUT.n94 EAOUT.n95 0.1445
R5213 EAOUT.n93 EAOUT.n94 0.1445
R5214 EAOUT.n92 EAOUT.n93 0.1445
R5215 EAOUT.n91 EAOUT.n92 0.1445
R5216 EAOUT.n90 EAOUT.n91 0.1445
R5217 EAOUT.n89 EAOUT.n90 0.1445
R5218 EAOUT.n88 EAOUT.n89 0.1445
R5219 EAOUT.n87 EAOUT.n88 0.1445
R5220 EAOUT.n86 EAOUT.n87 0.1445
R5221 EAOUT.n85 EAOUT.n86 0.1445
R5222 EAOUT.n84 EAOUT.n85 0.1445
R5223 EAOUT.n83 EAOUT.n84 0.1445
R5224 EAOUT.n82 EAOUT.n83 0.1445
R5225 EAOUT.n81 EAOUT.n82 0.1445
R5226 EAOUT.n80 EAOUT.n81 0.1445
R5227 EAOUT.n79 EAOUT.n80 0.1445
R5228 EAOUT.n78 EAOUT.n79 0.1445
R5229 EAOUT.n77 EAOUT.n78 0.1445
R5230 EAOUT.n76 EAOUT.n77 0.1445
R5231 EAOUT.n75 EAOUT.n76 0.1445
R5232 EAOUT.n74 EAOUT.n75 0.1445
R5233 EAOUT.n73 EAOUT.n74 0.1445
R5234 EAOUT.n72 EAOUT.n73 0.1445
R5235 EAOUT.n71 EAOUT.n72 0.1445
R5236 EAOUT.n70 EAOUT.n71 0.1445
R5237 EAOUT.n69 EAOUT.n70 0.1445
R5238 EAOUT.n68 EAOUT.n69 0.1445
R5239 EAOUT.n67 EAOUT.n68 0.1445
R5240 EAOUT.n66 EAOUT.n67 0.1445
R5241 EAOUT.n65 EAOUT.n66 0.1445
R5242 EAOUT.n64 EAOUT.n65 0.1445
R5243 EAOUT.n63 EAOUT.n64 0.1445
R5244 EAOUT.n62 EAOUT.n63 0.1445
R5245 EAOUT.n61 EAOUT.n62 0.1445
R5246 EAOUT.n60 EAOUT.n61 0.1445
R5247 EAOUT.n59 EAOUT.n60 0.1445
R5248 EAOUT.n58 EAOUT.n59 0.1445
R5249 EAOUT.n57 EAOUT.n58 0.1445
R5250 EAOUT.n56 EAOUT.n57 0.1445
R5251 EAOUT.n55 EAOUT.n56 0.1445
R5252 EAOUT.n54 EAOUT.n55 0.1445
R5253 EAOUT.n53 EAOUT.n54 0.1445
R5254 EAOUT.n52 EAOUT.n53 0.1445
R5255 EAOUT.n51 EAOUT.n52 0.1445
R5256 EAOUT.n50 EAOUT.n51 0.1445
R5257 EAOUT.n49 EAOUT.n50 0.1445
R5258 EAOUT.n48 EAOUT.n49 0.1445
R5259 EAOUT.n641 EAOUT.n48 0.0797
R5260 EAOUT.n641 EAOUT.n47 0.0653
R5261 EAOUT.n47 EAOUT.n46 0.1445
R5262 EAOUT.n46 EAOUT.n45 0.1445
R5263 EAOUT.n45 EAOUT.n44 0.1445
R5264 EAOUT.n44 EAOUT.n43 0.1445
R5265 EAOUT.n43 EAOUT.n42 0.1445
R5266 EAOUT.n42 EAOUT.n41 0.1445
R5267 EAOUT.n41 EAOUT.n40 0.1445
R5268 EAOUT.n40 EAOUT.n39 0.1445
R5269 EAOUT.n39 EAOUT.n38 0.1445
R5270 EAOUT.n38 EAOUT.n37 0.1445
R5271 EAOUT.n37 EAOUT.n36 0.1445
R5272 EAOUT.n36 EAOUT.n35 0.1445
R5273 EAOUT.n35 EAOUT.n34 0.1445
R5274 EAOUT.n34 EAOUT.n33 0.1445
R5275 EAOUT.n33 EAOUT.n32 0.1445
R5276 EAOUT.n32 EAOUT.n31 0.1445
R5277 EAOUT.n31 EAOUT.n30 0.1445
R5278 EAOUT.n30 EAOUT.n29 0.1445
R5279 EAOUT.n29 EAOUT.n28 0.1445
R5280 EAOUT.n28 EAOUT.n27 0.1445
R5281 EAOUT.n27 EAOUT.n26 0.1445
R5282 EAOUT.n26 EAOUT.n25 0.1445
R5283 EAOUT.n25 EAOUT.n24 0.1445
R5284 EAOUT.n24 EAOUT.n23 0.1445
R5285 EAOUT.n23 EAOUT.n22 0.1445
R5286 EAOUT.n22 EAOUT.n21 0.1445
R5287 EAOUT.n21 EAOUT.n20 0.1445
R5288 EAOUT.n20 EAOUT.n19 0.1445
R5289 EAOUT.n19 EAOUT.n18 0.1445
R5290 EAOUT.n18 EAOUT.n17 0.1445
R5291 EAOUT.n17 EAOUT.n16 0.1445
R5292 EAOUT.n16 EAOUT.n15 0.1445
R5293 EAOUT.n15 EAOUT.n14 0.1445
R5294 EAOUT.n14 EAOUT.n13 0.1445
R5295 EAOUT.n13 EAOUT.n12 0.1445
R5296 EAOUT.n12 EAOUT.n11 0.1445
R5297 EAOUT.n11 EAOUT.n10 0.1445
R5298 EAOUT.n10 EAOUT.n640 5.8703
R5299 EAOUT.n430 EAOUT.n572 12.5005
R5300 EAOUT.n431 EAOUT.n573 12.5005
R5301 EAOUT.n432 EAOUT.n571 12.5005
R5302 EAOUT.n433 EAOUT.n570 12.5005
R5303 EAOUT.n434 EAOUT.n575 12.5005
R5304 EAOUT.n435 EAOUT.n576 12.5005
R5305 EAOUT.n436 EAOUT.n569 12.5005
R5306 EAOUT.n437 EAOUT.n568 12.5005
R5307 EAOUT.n438 EAOUT.n578 12.5005
R5308 EAOUT.n439 EAOUT.n567 12.5005
R5309 EAOUT.n440 EAOUT.n566 12.5005
R5310 EAOUT.n441 EAOUT.n579 12.5005
R5311 EAOUT.n442 EAOUT.n580 12.5005
R5312 EAOUT.n443 EAOUT.n565 12.5005
R5313 EAOUT.n444 EAOUT.n564 12.5005
R5314 EAOUT.n445 EAOUT.n582 12.5005
R5315 EAOUT.n446 EAOUT.n583 12.5005
R5316 EAOUT.n447 EAOUT.n563 12.5005
R5317 EAOUT.n448 EAOUT.n584 12.5005
R5318 EAOUT.n449 EAOUT.n585 12.5005
R5319 EAOUT.n450 EAOUT.n562 12.5005
R5320 EAOUT.n451 EAOUT.n561 12.5005
R5321 EAOUT.n452 EAOUT.n587 12.5005
R5322 EAOUT.n453 EAOUT.n588 12.5005
R5323 EAOUT.n454 EAOUT.n560 12.5005
R5324 EAOUT.n455 EAOUT.n559 12.5005
R5325 EAOUT.n456 EAOUT.n590 12.5005
R5326 EAOUT.n457 EAOUT.n558 12.5005
R5327 EAOUT.n458 EAOUT.n557 12.5005
R5328 EAOUT.n459 EAOUT.n592 12.5005
R5329 EAOUT.n460 EAOUT.n593 12.5005
R5330 EAOUT.n461 EAOUT.n556 12.5005
R5331 EAOUT.n462 EAOUT.n555 12.5005
R5332 EAOUT.n463 EAOUT.n595 12.5005
R5333 EAOUT.n464 EAOUT.n596 12.5005
R5334 EAOUT.n465 EAOUT.n554 12.5005
R5335 EAOUT.n466 EAOUT.n597 12.5005
R5336 EAOUT.n467 EAOUT.n598 12.5005
R5337 EAOUT.n468 EAOUT.n553 12.5005
R5338 EAOUT.n469 EAOUT.n552 12.5005
R5339 EAOUT.n470 EAOUT.n600 12.5005
R5340 EAOUT.n471 EAOUT.n601 12.5005
R5341 EAOUT.n472 EAOUT.n551 12.5005
R5342 EAOUT.n473 EAOUT.n550 12.5005
R5343 EAOUT.n474 EAOUT.n603 12.5005
R5344 EAOUT.n475 EAOUT.n549 12.5005
R5345 EAOUT.n476 EAOUT.n548 12.5005
R5346 EAOUT.n477 EAOUT.n605 12.5005
R5347 EAOUT.n478 EAOUT.n606 12.5005
R5348 EAOUT.n479 EAOUT.n547 12.5005
R5349 EAOUT.n480 EAOUT.n546 12.5005
R5350 EAOUT.n481 EAOUT.n608 12.5005
R5351 EAOUT.n482 EAOUT.n545 12.5005
R5352 EAOUT.n483 EAOUT.n544 12.5005
R5353 EAOUT.n484 EAOUT.n610 12.5005
R5354 EAOUT.n485 EAOUT.n611 12.5005
R5355 EAOUT.n486 EAOUT.n543 12.5005
R5356 EAOUT.n487 EAOUT.n542 12.5005
R5357 EAOUT.n488 EAOUT.n613 12.5005
R5358 EAOUT.n489 EAOUT.n614 12.5005
R5359 EAOUT.n490 EAOUT.n541 12.5005
R5360 EAOUT.n491 EAOUT.n615 12.5005
R5361 EAOUT.n492 EAOUT.n616 12.5005
R5362 EAOUT.n493 EAOUT.n540 12.5005
R5363 EAOUT.n494 EAOUT.n539 12.5005
R5364 EAOUT.n495 EAOUT.n618 12.5005
R5365 EAOUT.n496 EAOUT.n619 12.5005
R5366 EAOUT.n497 EAOUT.n538 12.5005
R5367 EAOUT.n498 EAOUT.n537 12.5005
R5368 EAOUT.n499 EAOUT.n621 12.5005
R5369 EAOUT.n500 EAOUT.n536 12.5005
R5370 EAOUT.n501 EAOUT.n535 12.5005
R5371 EAOUT.n502 EAOUT.n623 12.5005
R5372 EAOUT.n503 EAOUT.n624 12.5005
R5373 EAOUT.n504 EAOUT.n534 12.5005
R5374 EAOUT.n505 EAOUT.n533 12.5005
R5375 EAOUT.n506 EAOUT.n626 12.5005
R5376 EAOUT.n507 EAOUT.n627 12.5005
R5377 EAOUT.n508 EAOUT.n532 12.5005
R5378 EAOUT.n509 EAOUT.n628 12.5005
R5379 EAOUT.n510 EAOUT.n629 12.5005
R5380 EAOUT.n511 EAOUT.n531 12.5005
R5381 EAOUT.n512 EAOUT.n530 12.5005
R5382 EAOUT.n513 EAOUT.n631 12.5005
R5383 EAOUT.n514 EAOUT.n632 12.5005
R5384 EAOUT.n515 EAOUT.n529 12.5005
R5385 EAOUT.n516 EAOUT.n633 12.5005
R5386 EAOUT.n517 EAOUT.n634 12.5005
R5387 EAOUT.n518 EAOUT.n528 12.5005
R5388 EAOUT.n519 EAOUT.n527 12.5005
R5389 EAOUT.n520 EAOUT.n636 12.5005
R5390 EAOUT.n521 EAOUT.n637 12.5005
R5391 EAOUT.n522 EAOUT.n526 12.5005
R5392 EAOUT.n523 EAOUT.n525 12.5005
R5393 EAOUT.n524 EAOUT.n639 2.98483
R5394 EAOUT.n523 EAOUT.n524 4.93033
R5395 EAOUT.n522 EAOUT.n523 0.1445
R5396 EAOUT.n521 EAOUT.n522 0.1445
R5397 EAOUT.n520 EAOUT.n521 0.1445
R5398 EAOUT.n519 EAOUT.n520 0.1445
R5399 EAOUT.n518 EAOUT.n519 0.1445
R5400 EAOUT.n517 EAOUT.n518 0.1445
R5401 EAOUT.n516 EAOUT.n517 0.1445
R5402 EAOUT.n515 EAOUT.n516 0.1445
R5403 EAOUT.n514 EAOUT.n515 0.1445
R5404 EAOUT.n513 EAOUT.n514 0.1445
R5405 EAOUT.n512 EAOUT.n513 0.1445
R5406 EAOUT.n511 EAOUT.n512 0.1445
R5407 EAOUT.n510 EAOUT.n511 0.1445
R5408 EAOUT.n509 EAOUT.n510 0.1445
R5409 EAOUT.n508 EAOUT.n509 0.1445
R5410 EAOUT.n507 EAOUT.n508 0.1445
R5411 EAOUT.n506 EAOUT.n507 0.1445
R5412 EAOUT.n505 EAOUT.n506 0.1445
R5413 EAOUT.n504 EAOUT.n505 0.1445
R5414 EAOUT.n503 EAOUT.n504 0.1445
R5415 EAOUT.n502 EAOUT.n503 0.1445
R5416 EAOUT.n501 EAOUT.n502 0.1445
R5417 EAOUT.n500 EAOUT.n501 0.1445
R5418 EAOUT.n499 EAOUT.n500 0.1445
R5419 EAOUT.n498 EAOUT.n499 0.1445
R5420 EAOUT.n497 EAOUT.n498 0.1445
R5421 EAOUT.n496 EAOUT.n497 0.1445
R5422 EAOUT.n495 EAOUT.n496 0.1445
R5423 EAOUT.n494 EAOUT.n495 0.1445
R5424 EAOUT.n493 EAOUT.n494 0.1445
R5425 EAOUT.n492 EAOUT.n493 0.1445
R5426 EAOUT.n491 EAOUT.n492 0.1445
R5427 EAOUT.n490 EAOUT.n491 0.1445
R5428 EAOUT.n489 EAOUT.n490 0.1445
R5429 EAOUT.n488 EAOUT.n489 0.1445
R5430 EAOUT.n487 EAOUT.n488 0.1445
R5431 EAOUT.n486 EAOUT.n487 0.1445
R5432 EAOUT.n485 EAOUT.n486 0.1445
R5433 EAOUT.n484 EAOUT.n485 0.1445
R5434 EAOUT.n483 EAOUT.n484 0.1445
R5435 EAOUT.n482 EAOUT.n483 0.1445
R5436 EAOUT.n481 EAOUT.n482 0.1445
R5437 EAOUT.n480 EAOUT.n481 0.1445
R5438 EAOUT.n479 EAOUT.n480 0.1445
R5439 EAOUT.n478 EAOUT.n479 0.1445
R5440 EAOUT.n477 EAOUT.n478 0.1445
R5441 EAOUT.n476 EAOUT.n477 0.1445
R5442 EAOUT.n475 EAOUT.n476 0.1445
R5443 EAOUT.n474 EAOUT.n475 0.1445
R5444 EAOUT.n473 EAOUT.n474 0.1445
R5445 EAOUT.n472 EAOUT.n473 0.1445
R5446 EAOUT.n471 EAOUT.n472 0.1445
R5447 EAOUT.n470 EAOUT.n471 0.1445
R5448 EAOUT.n469 EAOUT.n470 0.1445
R5449 EAOUT.n468 EAOUT.n469 0.1445
R5450 EAOUT.n467 EAOUT.n468 0.1445
R5451 EAOUT.n466 EAOUT.n467 0.1445
R5452 EAOUT.n465 EAOUT.n466 0.1445
R5453 EAOUT.n464 EAOUT.n465 0.1445
R5454 EAOUT.n463 EAOUT.n464 0.1445
R5455 EAOUT.n462 EAOUT.n463 0.1445
R5456 EAOUT.n461 EAOUT.n462 0.1445
R5457 EAOUT.n460 EAOUT.n461 0.1445
R5458 EAOUT.n459 EAOUT.n460 0.1445
R5459 EAOUT.n458 EAOUT.n459 0.1445
R5460 EAOUT.n457 EAOUT.n458 0.1445
R5461 EAOUT.n456 EAOUT.n457 0.1445
R5462 EAOUT.n455 EAOUT.n456 0.1445
R5463 EAOUT.n454 EAOUT.n455 0.1445
R5464 EAOUT.n453 EAOUT.n454 0.1445
R5465 EAOUT.n452 EAOUT.n453 0.1445
R5466 EAOUT.n451 EAOUT.n452 0.1445
R5467 EAOUT.n450 EAOUT.n451 0.1445
R5468 EAOUT.n449 EAOUT.n450 0.1445
R5469 EAOUT.n448 EAOUT.n449 0.1445
R5470 EAOUT.n447 EAOUT.n448 0.1445
R5471 EAOUT.n446 EAOUT.n447 0.1445
R5472 EAOUT.n445 EAOUT.n446 0.1445
R5473 EAOUT.n444 EAOUT.n445 0.1445
R5474 EAOUT.n443 EAOUT.n444 0.1445
R5475 EAOUT.n442 EAOUT.n443 0.1445
R5476 EAOUT.n441 EAOUT.n442 0.1445
R5477 EAOUT.n440 EAOUT.n441 0.1445
R5478 EAOUT.n439 EAOUT.n440 0.1445
R5479 EAOUT.n438 EAOUT.n439 0.1445
R5480 EAOUT.n437 EAOUT.n438 0.1445
R5481 EAOUT.n436 EAOUT.n437 0.1445
R5482 EAOUT.n435 EAOUT.n436 0.1445
R5483 EAOUT.n434 EAOUT.n435 0.1445
R5484 EAOUT.n433 EAOUT.n434 0.1445
R5485 EAOUT.n432 EAOUT.n433 0.1445
R5486 EAOUT.n431 EAOUT.n432 0.1445
R5487 EAOUT.n430 EAOUT.n431 0.1445
R5488 EAOUT.n640 EAOUT.n430 4.7561
R5489 EAOUT.n524 EAOUT.t154 33.7058
R5490 EAOUT.n639 EAOUT.t153 30.395
R5491 EAOUT.n639 EAOUT.n525 7.4465
R5492 EAOUT.n525 EAOUT.n638 0.7305
R5493 EAOUT.n638 EAOUT.t152 30.395
R5494 EAOUT.n638 EAOUT.n526 2.9205
R5495 EAOUT.n526 EAOUT.n637 5.2565
R5496 EAOUT.n637 EAOUT.t151 30.395
R5497 EAOUT.n637 EAOUT.n636 8.1765
R5498 EAOUT.n636 EAOUT.t150 30.395
R5499 EAOUT.n636 EAOUT.n527 5.5485
R5500 EAOUT.n527 EAOUT.n635 2.6285
R5501 EAOUT.n635 EAOUT.t149 30.395
R5502 EAOUT.n528 EAOUT.n635 1.0225
R5503 EAOUT.n528 EAOUT.n634 7.1545
R5504 EAOUT.n634 EAOUT.t148 30.395
R5505 EAOUT.n634 EAOUT.n633 8.1765
R5506 EAOUT.n633 EAOUT.t147 30.395
R5507 EAOUT.n633 EAOUT.n529 3.6505
R5508 EAOUT.n529 EAOUT.n632 4.5265
R5509 EAOUT.n632 EAOUT.t146 30.395
R5510 EAOUT.n632 EAOUT.n631 8.1765
R5511 EAOUT.n631 EAOUT.t145 30.395
R5512 EAOUT.n631 EAOUT.n530 6.2785
R5513 EAOUT.n530 EAOUT.n630 1.8985
R5514 EAOUT.n630 EAOUT.t144 30.395
R5515 EAOUT.n531 EAOUT.n630 1.7525
R5516 EAOUT.n531 EAOUT.n629 6.4245
R5517 EAOUT.n629 EAOUT.t143 30.395
R5518 EAOUT.n629 EAOUT.n628 8.1765
R5519 EAOUT.n628 EAOUT.t142 30.395
R5520 EAOUT.n628 EAOUT.n532 4.3805
R5521 EAOUT.n532 EAOUT.n627 3.7965
R5522 EAOUT.n627 EAOUT.t141 30.395
R5523 EAOUT.n627 EAOUT.n626 8.1765
R5524 EAOUT.n626 EAOUT.t140 30.395
R5525 EAOUT.n626 EAOUT.n533 7.0085
R5526 EAOUT.n533 EAOUT.n625 1.1685
R5527 EAOUT.n625 EAOUT.t139 30.395
R5528 EAOUT.n625 EAOUT.n534 2.4825
R5529 EAOUT.n534 EAOUT.n624 5.6945
R5530 EAOUT.n624 EAOUT.t138 30.395
R5531 EAOUT.n624 EAOUT.n623 8.1765
R5532 EAOUT.n623 EAOUT.t137 30.395
R5533 EAOUT.n623 EAOUT.n535 5.1105
R5534 EAOUT.n535 EAOUT.n622 3.0665
R5535 EAOUT.n622 EAOUT.t136 30.395
R5536 EAOUT.n536 EAOUT.n622 0.5845
R5537 EAOUT.n536 EAOUT.n621 7.5925
R5538 EAOUT.n621 EAOUT.t135 30.395
R5539 EAOUT.n621 EAOUT.n537 7.7385
R5540 EAOUT.n537 EAOUT.n620 0.4385
R5541 EAOUT.n620 EAOUT.t134 30.395
R5542 EAOUT.n620 EAOUT.n538 3.2125
R5543 EAOUT.n538 EAOUT.n619 4.9645
R5544 EAOUT.n619 EAOUT.t133 30.395
R5545 EAOUT.n619 EAOUT.n618 8.1765
R5546 EAOUT.n618 EAOUT.t132 30.395
R5547 EAOUT.n618 EAOUT.n539 5.8405
R5548 EAOUT.n539 EAOUT.n617 2.3365
R5549 EAOUT.n617 EAOUT.t131 30.395
R5550 EAOUT.n540 EAOUT.n617 1.3145
R5551 EAOUT.n540 EAOUT.n616 6.8625
R5552 EAOUT.n616 EAOUT.t130 30.395
R5553 EAOUT.n616 EAOUT.n615 8.1765
R5554 EAOUT.n615 EAOUT.t129 30.395
R5555 EAOUT.n615 EAOUT.n541 3.9425
R5556 EAOUT.n541 EAOUT.n614 4.2345
R5557 EAOUT.n614 EAOUT.t128 30.395
R5558 EAOUT.n614 EAOUT.n613 8.1765
R5559 EAOUT.n613 EAOUT.t127 30.395
R5560 EAOUT.n613 EAOUT.n542 6.5705
R5561 EAOUT.n542 EAOUT.n612 1.6065
R5562 EAOUT.n612 EAOUT.t126 30.395
R5563 EAOUT.n612 EAOUT.n543 2.0445
R5564 EAOUT.n543 EAOUT.n611 6.1325
R5565 EAOUT.n611 EAOUT.t125 30.395
R5566 EAOUT.n611 EAOUT.n610 8.1765
R5567 EAOUT.n610 EAOUT.t124 30.395
R5568 EAOUT.n610 EAOUT.n544 4.6725
R5569 EAOUT.n544 EAOUT.n609 3.5045
R5570 EAOUT.n609 EAOUT.t123 30.395
R5571 EAOUT.n545 EAOUT.n609 0.1465
R5572 EAOUT.n545 EAOUT.n608 8.0305
R5573 EAOUT.n608 EAOUT.t122 30.395
R5574 EAOUT.n608 EAOUT.n546 7.3005
R5575 EAOUT.n546 EAOUT.n607 0.8765
R5576 EAOUT.n607 EAOUT.t121 30.395
R5577 EAOUT.n607 EAOUT.n547 2.7745
R5578 EAOUT.n547 EAOUT.n606 5.4025
R5579 EAOUT.n606 EAOUT.t120 30.395
R5580 EAOUT.n606 EAOUT.n605 8.1765
R5581 EAOUT.n605 EAOUT.t119 30.395
R5582 EAOUT.n605 EAOUT.n548 5.4025
R5583 EAOUT.n548 EAOUT.n604 2.7745
R5584 EAOUT.n604 EAOUT.t118 30.395
R5585 EAOUT.n549 EAOUT.n604 0.8765
R5586 EAOUT.n549 EAOUT.n603 7.3005
R5587 EAOUT.n603 EAOUT.t117 30.395
R5588 EAOUT.n603 EAOUT.n550 8.0305
R5589 EAOUT.n550 EAOUT.n602 0.1465
R5590 EAOUT.n602 EAOUT.t116 30.395
R5591 EAOUT.n602 EAOUT.n551 3.5045
R5592 EAOUT.n551 EAOUT.n601 4.6725
R5593 EAOUT.n601 EAOUT.t115 30.395
R5594 EAOUT.n601 EAOUT.n600 8.1765
R5595 EAOUT.n600 EAOUT.t114 30.395
R5596 EAOUT.n600 EAOUT.n552 6.1325
R5597 EAOUT.n552 EAOUT.n599 2.0445
R5598 EAOUT.n599 EAOUT.t113 30.395
R5599 EAOUT.n553 EAOUT.n599 1.6065
R5600 EAOUT.n553 EAOUT.n598 6.5705
R5601 EAOUT.n598 EAOUT.t112 30.395
R5602 EAOUT.n598 EAOUT.n597 8.1765
R5603 EAOUT.n597 EAOUT.t111 30.395
R5604 EAOUT.n597 EAOUT.n554 4.2345
R5605 EAOUT.n554 EAOUT.n596 3.9425
R5606 EAOUT.n596 EAOUT.t110 30.395
R5607 EAOUT.n596 EAOUT.n595 8.1765
R5608 EAOUT.n595 EAOUT.t109 30.395
R5609 EAOUT.n595 EAOUT.n555 6.8625
R5610 EAOUT.n555 EAOUT.n594 1.3145
R5611 EAOUT.n594 EAOUT.t108 30.395
R5612 EAOUT.n594 EAOUT.n556 2.3365
R5613 EAOUT.n556 EAOUT.n593 5.8405
R5614 EAOUT.n593 EAOUT.t107 30.395
R5615 EAOUT.n593 EAOUT.n592 8.1765
R5616 EAOUT.n592 EAOUT.t106 30.395
R5617 EAOUT.n592 EAOUT.n557 4.9645
R5618 EAOUT.n557 EAOUT.n591 3.2125
R5619 EAOUT.n591 EAOUT.t105 30.395
R5620 EAOUT.n558 EAOUT.n591 0.4385
R5621 EAOUT.n558 EAOUT.n590 7.7385
R5622 EAOUT.n590 EAOUT.t104 30.395
R5623 EAOUT.n590 EAOUT.n559 7.5925
R5624 EAOUT.n559 EAOUT.n589 0.5845
R5625 EAOUT.n589 EAOUT.t103 30.395
R5626 EAOUT.n589 EAOUT.n560 3.0665
R5627 EAOUT.n560 EAOUT.n588 5.1105
R5628 EAOUT.n588 EAOUT.t102 30.395
R5629 EAOUT.n588 EAOUT.n587 8.1765
R5630 EAOUT.n587 EAOUT.t101 30.395
R5631 EAOUT.n587 EAOUT.n561 5.6945
R5632 EAOUT.n561 EAOUT.n586 2.4825
R5633 EAOUT.n586 EAOUT.t100 30.395
R5634 EAOUT.n562 EAOUT.n586 1.1685
R5635 EAOUT.n562 EAOUT.n585 7.0085
R5636 EAOUT.n585 EAOUT.t99 30.395
R5637 EAOUT.n585 EAOUT.n584 8.1765
R5638 EAOUT.n584 EAOUT.t98 30.395
R5639 EAOUT.n584 EAOUT.n563 3.7965
R5640 EAOUT.n563 EAOUT.n583 4.3805
R5641 EAOUT.n583 EAOUT.t97 30.395
R5642 EAOUT.n583 EAOUT.n582 8.1765
R5643 EAOUT.n582 EAOUT.t96 30.395
R5644 EAOUT.n582 EAOUT.n564 6.4245
R5645 EAOUT.n564 EAOUT.n581 1.7525
R5646 EAOUT.n581 EAOUT.t95 30.395
R5647 EAOUT.n581 EAOUT.n565 1.8985
R5648 EAOUT.n565 EAOUT.n580 6.2785
R5649 EAOUT.n580 EAOUT.t94 30.395
R5650 EAOUT.n580 EAOUT.n579 8.1765
R5651 EAOUT.n579 EAOUT.t93 30.395
R5652 EAOUT.n579 EAOUT.n566 4.5265
R5653 EAOUT.n566 EAOUT.n567 3.6505
R5654 EAOUT.n567 EAOUT.t92 30.395
R5655 EAOUT.n567 EAOUT.n578 8.1765
R5656 EAOUT.n578 EAOUT.t91 30.395
R5657 EAOUT.n578 EAOUT.n568 7.1545
R5658 EAOUT.n568 EAOUT.n577 1.0225
R5659 EAOUT.n577 EAOUT.t90 30.395
R5660 EAOUT.n577 EAOUT.n569 2.6285
R5661 EAOUT.n569 EAOUT.n576 5.5485
R5662 EAOUT.n576 EAOUT.t89 30.395
R5663 EAOUT.n576 EAOUT.n575 8.1765
R5664 EAOUT.n575 EAOUT.t88 30.395
R5665 EAOUT.n575 EAOUT.n570 5.2565
R5666 EAOUT.n570 EAOUT.n574 2.9205
R5667 EAOUT.n574 EAOUT.t87 30.395
R5668 EAOUT.n571 EAOUT.n574 0.7305
R5669 EAOUT.n571 EAOUT.n573 7.4465
R5670 EAOUT.n573 EAOUT.t86 30.395
R5671 EAOUT.n573 EAOUT.n572 7.8845
R5672 EAOUT.n572 EAOUT.t85 30.687
R5673 EAOUT.n220 EAOUT.n360 2.98483
R5674 EAOUT.n221 EAOUT.n359 12.5005
R5675 EAOUT.n222 EAOUT.n358 12.5005
R5676 EAOUT.n223 EAOUT.n362 12.5005
R5677 EAOUT.n224 EAOUT.n363 12.5005
R5678 EAOUT.n225 EAOUT.n357 12.5005
R5679 EAOUT.n226 EAOUT.n356 12.5005
R5680 EAOUT.n227 EAOUT.n365 12.5005
R5681 EAOUT.n228 EAOUT.n366 12.5005
R5682 EAOUT.n229 EAOUT.n355 12.5005
R5683 EAOUT.n230 EAOUT.n367 12.5005
R5684 EAOUT.n231 EAOUT.n368 12.5005
R5685 EAOUT.n232 EAOUT.n354 12.5005
R5686 EAOUT.n233 EAOUT.n353 12.5005
R5687 EAOUT.n234 EAOUT.n370 12.5005
R5688 EAOUT.n235 EAOUT.n371 12.5005
R5689 EAOUT.n236 EAOUT.n352 12.5005
R5690 EAOUT.n237 EAOUT.n372 12.5005
R5691 EAOUT.n238 EAOUT.n373 12.5005
R5692 EAOUT.n239 EAOUT.n351 12.5005
R5693 EAOUT.n240 EAOUT.n350 12.5005
R5694 EAOUT.n241 EAOUT.n375 12.5005
R5695 EAOUT.n242 EAOUT.n376 12.5005
R5696 EAOUT.n243 EAOUT.n349 12.5005
R5697 EAOUT.n244 EAOUT.n348 12.5005
R5698 EAOUT.n245 EAOUT.n378 12.5005
R5699 EAOUT.n246 EAOUT.n347 12.5005
R5700 EAOUT.n247 EAOUT.n346 12.5005
R5701 EAOUT.n248 EAOUT.n380 12.5005
R5702 EAOUT.n249 EAOUT.n381 12.5005
R5703 EAOUT.n250 EAOUT.n345 12.5005
R5704 EAOUT.n251 EAOUT.n344 12.5005
R5705 EAOUT.n252 EAOUT.n383 12.5005
R5706 EAOUT.n253 EAOUT.n384 12.5005
R5707 EAOUT.n254 EAOUT.n343 12.5005
R5708 EAOUT.n255 EAOUT.n385 12.5005
R5709 EAOUT.n256 EAOUT.n386 12.5005
R5710 EAOUT.n257 EAOUT.n342 12.5005
R5711 EAOUT.n258 EAOUT.n341 12.5005
R5712 EAOUT.n259 EAOUT.n388 12.5005
R5713 EAOUT.n260 EAOUT.n389 12.5005
R5714 EAOUT.n261 EAOUT.n340 12.5005
R5715 EAOUT.n262 EAOUT.n339 12.5005
R5716 EAOUT.n263 EAOUT.n391 12.5005
R5717 EAOUT.n264 EAOUT.n338 12.5005
R5718 EAOUT.n265 EAOUT.n337 12.5005
R5719 EAOUT.n266 EAOUT.n393 12.5005
R5720 EAOUT.n267 EAOUT.n394 12.5005
R5721 EAOUT.n268 EAOUT.n336 12.5005
R5722 EAOUT.n269 EAOUT.n335 12.5005
R5723 EAOUT.n270 EAOUT.n396 12.5005
R5724 EAOUT.n271 EAOUT.n334 12.5005
R5725 EAOUT.n272 EAOUT.n333 12.5005
R5726 EAOUT.n273 EAOUT.n398 12.5005
R5727 EAOUT.n274 EAOUT.n399 12.5005
R5728 EAOUT.n275 EAOUT.n332 12.5005
R5729 EAOUT.n276 EAOUT.n331 12.5005
R5730 EAOUT.n277 EAOUT.n401 12.5005
R5731 EAOUT.n278 EAOUT.n402 12.5005
R5732 EAOUT.n279 EAOUT.n330 12.5005
R5733 EAOUT.n280 EAOUT.n403 12.5005
R5734 EAOUT.n281 EAOUT.n404 12.5005
R5735 EAOUT.n282 EAOUT.n329 12.5005
R5736 EAOUT.n283 EAOUT.n328 12.5005
R5737 EAOUT.n284 EAOUT.n406 12.5005
R5738 EAOUT.n285 EAOUT.n407 12.5005
R5739 EAOUT.n286 EAOUT.n327 12.5005
R5740 EAOUT.n287 EAOUT.n326 12.5005
R5741 EAOUT.n288 EAOUT.n409 12.5005
R5742 EAOUT.n289 EAOUT.n325 12.5005
R5743 EAOUT.n290 EAOUT.n324 12.5005
R5744 EAOUT.n291 EAOUT.n411 12.5005
R5745 EAOUT.n292 EAOUT.n412 12.5005
R5746 EAOUT.n293 EAOUT.n323 12.5005
R5747 EAOUT.n294 EAOUT.n322 12.5005
R5748 EAOUT.n295 EAOUT.n414 12.5005
R5749 EAOUT.n296 EAOUT.n415 12.5005
R5750 EAOUT.n297 EAOUT.n321 12.5005
R5751 EAOUT.n298 EAOUT.n416 12.5005
R5752 EAOUT.n299 EAOUT.n417 12.5005
R5753 EAOUT.n300 EAOUT.n320 12.5005
R5754 EAOUT.n301 EAOUT.n319 12.5005
R5755 EAOUT.n302 EAOUT.n419 12.5005
R5756 EAOUT.n303 EAOUT.n420 12.5005
R5757 EAOUT.n304 EAOUT.n318 12.5005
R5758 EAOUT.n305 EAOUT.n421 12.5005
R5759 EAOUT.n306 EAOUT.n422 12.5005
R5760 EAOUT.n307 EAOUT.n317 12.5005
R5761 EAOUT.n308 EAOUT.n316 12.5005
R5762 EAOUT.n309 EAOUT.n424 12.5005
R5763 EAOUT.n310 EAOUT.n425 12.5005
R5764 EAOUT.n311 EAOUT.n315 12.5005
R5765 EAOUT.n312 EAOUT.n314 12.5005
R5766 EAOUT.n313 EAOUT.n427 12.5005
R5767 EAOUT.n221 EAOUT.n220 4.93033
R5768 EAOUT.n222 EAOUT.n221 0.1445
R5769 EAOUT.n223 EAOUT.n222 0.1445
R5770 EAOUT.n224 EAOUT.n223 0.1445
R5771 EAOUT.n225 EAOUT.n224 0.1445
R5772 EAOUT.n226 EAOUT.n225 0.1445
R5773 EAOUT.n227 EAOUT.n226 0.1445
R5774 EAOUT.n228 EAOUT.n227 0.1445
R5775 EAOUT.n229 EAOUT.n228 0.1445
R5776 EAOUT.n230 EAOUT.n229 0.1445
R5777 EAOUT.n231 EAOUT.n230 0.1445
R5778 EAOUT.n232 EAOUT.n231 0.1445
R5779 EAOUT.n233 EAOUT.n232 0.1445
R5780 EAOUT.n234 EAOUT.n233 0.1445
R5781 EAOUT.n235 EAOUT.n234 0.1445
R5782 EAOUT.n236 EAOUT.n235 0.1445
R5783 EAOUT.n237 EAOUT.n236 0.1445
R5784 EAOUT.n238 EAOUT.n237 0.1445
R5785 EAOUT.n239 EAOUT.n238 0.1445
R5786 EAOUT.n240 EAOUT.n239 0.1445
R5787 EAOUT.n241 EAOUT.n240 0.1445
R5788 EAOUT.n242 EAOUT.n241 0.1445
R5789 EAOUT.n243 EAOUT.n242 0.1445
R5790 EAOUT.n244 EAOUT.n243 0.1445
R5791 EAOUT.n245 EAOUT.n244 0.1445
R5792 EAOUT.n246 EAOUT.n245 0.1445
R5793 EAOUT.n247 EAOUT.n246 0.1445
R5794 EAOUT.n248 EAOUT.n247 0.1445
R5795 EAOUT.n249 EAOUT.n248 0.1445
R5796 EAOUT.n250 EAOUT.n249 0.1445
R5797 EAOUT.n251 EAOUT.n250 0.1445
R5798 EAOUT.n252 EAOUT.n251 0.1445
R5799 EAOUT.n253 EAOUT.n252 0.1445
R5800 EAOUT.n254 EAOUT.n253 0.1445
R5801 EAOUT.n255 EAOUT.n254 0.1445
R5802 EAOUT.n256 EAOUT.n255 0.1445
R5803 EAOUT.n257 EAOUT.n256 0.1445
R5804 EAOUT.n258 EAOUT.n257 0.1445
R5805 EAOUT.n259 EAOUT.n258 0.1445
R5806 EAOUT.n260 EAOUT.n259 0.1445
R5807 EAOUT.n261 EAOUT.n260 0.1445
R5808 EAOUT.n262 EAOUT.n261 0.1445
R5809 EAOUT.n263 EAOUT.n262 0.1445
R5810 EAOUT.n264 EAOUT.n263 0.1445
R5811 EAOUT.n265 EAOUT.n264 0.1445
R5812 EAOUT.n266 EAOUT.n265 0.1445
R5813 EAOUT.n267 EAOUT.n266 0.1445
R5814 EAOUT.n268 EAOUT.n267 0.1445
R5815 EAOUT.n269 EAOUT.n268 0.1445
R5816 EAOUT.n270 EAOUT.n269 0.1445
R5817 EAOUT.n271 EAOUT.n270 0.1445
R5818 EAOUT.n272 EAOUT.n271 0.1445
R5819 EAOUT.n273 EAOUT.n272 0.1445
R5820 EAOUT.n274 EAOUT.n273 0.1445
R5821 EAOUT.n275 EAOUT.n274 0.1445
R5822 EAOUT.n276 EAOUT.n275 0.1445
R5823 EAOUT.n277 EAOUT.n276 0.1445
R5824 EAOUT.n278 EAOUT.n277 0.1445
R5825 EAOUT.n279 EAOUT.n278 0.1445
R5826 EAOUT.n280 EAOUT.n279 0.1445
R5827 EAOUT.n281 EAOUT.n280 0.1445
R5828 EAOUT.n282 EAOUT.n281 0.1445
R5829 EAOUT.n283 EAOUT.n282 0.1445
R5830 EAOUT.n284 EAOUT.n283 0.1445
R5831 EAOUT.n285 EAOUT.n284 0.1445
R5832 EAOUT.n286 EAOUT.n285 0.1445
R5833 EAOUT.n287 EAOUT.n286 0.1445
R5834 EAOUT.n288 EAOUT.n287 0.1445
R5835 EAOUT.n289 EAOUT.n288 0.1445
R5836 EAOUT.n290 EAOUT.n289 0.1445
R5837 EAOUT.n291 EAOUT.n290 0.1445
R5838 EAOUT.n292 EAOUT.n291 0.1445
R5839 EAOUT.n293 EAOUT.n292 0.1445
R5840 EAOUT.n294 EAOUT.n293 0.1445
R5841 EAOUT.n295 EAOUT.n294 0.1445
R5842 EAOUT.n296 EAOUT.n295 0.1445
R5843 EAOUT.n297 EAOUT.n296 0.1445
R5844 EAOUT.n298 EAOUT.n297 0.1445
R5845 EAOUT.n299 EAOUT.n298 0.1445
R5846 EAOUT.n300 EAOUT.n299 0.1445
R5847 EAOUT.n301 EAOUT.n300 0.1445
R5848 EAOUT.n302 EAOUT.n301 0.1445
R5849 EAOUT.n303 EAOUT.n302 0.1445
R5850 EAOUT.n304 EAOUT.n303 0.1445
R5851 EAOUT.n305 EAOUT.n304 0.1445
R5852 EAOUT.n306 EAOUT.n305 0.1445
R5853 EAOUT.n307 EAOUT.n306 0.1445
R5854 EAOUT.n308 EAOUT.n307 0.1445
R5855 EAOUT.n309 EAOUT.n308 0.1445
R5856 EAOUT.n310 EAOUT.n309 0.1445
R5857 EAOUT.n311 EAOUT.n310 0.1445
R5858 EAOUT.n312 EAOUT.n311 0.1445
R5859 EAOUT.n313 EAOUT.n312 0.1445
R5860 EAOUT.n429 EAOUT.n313 0.1445
R5861 EAOUT.n640 EAOUT.n429 5.8703
R5862 EAOUT.n429 EAOUT.n428 12.5005
R5863 EAOUT.n427 EAOUT.n428 7.8845
R5864 EAOUT.n428 EAOUT.t155 30.687
R5865 EAOUT.n427 EAOUT.t156 30.395
R5866 EAOUT.n314 EAOUT.n426 0.7305
R5867 EAOUT.n314 EAOUT.n427 7.4465
R5868 EAOUT.n426 EAOUT.t157 30.395
R5869 EAOUT.n425 EAOUT.n315 5.2565
R5870 EAOUT.n315 EAOUT.n426 2.9205
R5871 EAOUT.n425 EAOUT.t158 30.395
R5872 EAOUT.n424 EAOUT.n425 8.1765
R5873 EAOUT.n424 EAOUT.t159 30.395
R5874 EAOUT.n423 EAOUT.n316 2.6285
R5875 EAOUT.n316 EAOUT.n424 5.5485
R5876 EAOUT.n423 EAOUT.t160 30.395
R5877 EAOUT.n422 EAOUT.n317 7.1545
R5878 EAOUT.n317 EAOUT.n423 1.0225
R5879 EAOUT.n422 EAOUT.t161 30.395
R5880 EAOUT.n421 EAOUT.n422 8.1765
R5881 EAOUT.n421 EAOUT.t162 30.395
R5882 EAOUT.n420 EAOUT.n318 4.5265
R5883 EAOUT.n318 EAOUT.n421 3.6505
R5884 EAOUT.n420 EAOUT.t163 30.395
R5885 EAOUT.n419 EAOUT.n420 8.1765
R5886 EAOUT.n419 EAOUT.t164 30.395
R5887 EAOUT.n418 EAOUT.n319 1.8985
R5888 EAOUT.n319 EAOUT.n419 6.2785
R5889 EAOUT.n418 EAOUT.t165 30.395
R5890 EAOUT.n417 EAOUT.n320 6.4245
R5891 EAOUT.n320 EAOUT.n418 1.7525
R5892 EAOUT.n417 EAOUT.t166 30.395
R5893 EAOUT.n416 EAOUT.n417 8.1765
R5894 EAOUT.n416 EAOUT.t167 30.395
R5895 EAOUT.n415 EAOUT.n321 3.7965
R5896 EAOUT.n321 EAOUT.n416 4.3805
R5897 EAOUT.n415 EAOUT.t168 30.395
R5898 EAOUT.n414 EAOUT.n415 8.1765
R5899 EAOUT.n414 EAOUT.t169 30.395
R5900 EAOUT.n322 EAOUT.n413 1.1685
R5901 EAOUT.n322 EAOUT.n414 7.0085
R5902 EAOUT.n413 EAOUT.t170 30.395
R5903 EAOUT.n412 EAOUT.n323 5.6945
R5904 EAOUT.n323 EAOUT.n413 2.4825
R5905 EAOUT.n412 EAOUT.t171 30.395
R5906 EAOUT.n411 EAOUT.n412 8.1765
R5907 EAOUT.n411 EAOUT.t172 30.395
R5908 EAOUT.n410 EAOUT.n324 3.0665
R5909 EAOUT.n324 EAOUT.n411 5.1105
R5910 EAOUT.n410 EAOUT.t173 30.395
R5911 EAOUT.n409 EAOUT.n325 7.5925
R5912 EAOUT.n325 EAOUT.n410 0.5845
R5913 EAOUT.n409 EAOUT.t174 30.395
R5914 EAOUT.n326 EAOUT.n408 0.4385
R5915 EAOUT.n326 EAOUT.n409 7.7385
R5916 EAOUT.n408 EAOUT.t175 30.395
R5917 EAOUT.n407 EAOUT.n327 4.9645
R5918 EAOUT.n327 EAOUT.n408 3.2125
R5919 EAOUT.n407 EAOUT.t176 30.395
R5920 EAOUT.n406 EAOUT.n407 8.1765
R5921 EAOUT.n406 EAOUT.t177 30.395
R5922 EAOUT.n405 EAOUT.n328 2.3365
R5923 EAOUT.n328 EAOUT.n406 5.8405
R5924 EAOUT.n405 EAOUT.t178 30.395
R5925 EAOUT.n404 EAOUT.n329 6.8625
R5926 EAOUT.n329 EAOUT.n405 1.3145
R5927 EAOUT.n404 EAOUT.t179 30.395
R5928 EAOUT.n403 EAOUT.n404 8.1765
R5929 EAOUT.n403 EAOUT.t180 30.395
R5930 EAOUT.n402 EAOUT.n330 4.2345
R5931 EAOUT.n330 EAOUT.n403 3.9425
R5932 EAOUT.n402 EAOUT.t181 30.395
R5933 EAOUT.n401 EAOUT.n402 8.1765
R5934 EAOUT.n401 EAOUT.t182 30.395
R5935 EAOUT.n331 EAOUT.n400 1.6065
R5936 EAOUT.n331 EAOUT.n401 6.5705
R5937 EAOUT.n400 EAOUT.t183 30.395
R5938 EAOUT.n399 EAOUT.n332 6.1325
R5939 EAOUT.n332 EAOUT.n400 2.0445
R5940 EAOUT.n399 EAOUT.t184 30.395
R5941 EAOUT.n398 EAOUT.n399 8.1765
R5942 EAOUT.n398 EAOUT.t185 30.395
R5943 EAOUT.n397 EAOUT.n333 3.5045
R5944 EAOUT.n333 EAOUT.n398 4.6725
R5945 EAOUT.n397 EAOUT.t186 30.395
R5946 EAOUT.n396 EAOUT.n334 8.0305
R5947 EAOUT.n334 EAOUT.n397 0.1465
R5948 EAOUT.n396 EAOUT.t187 30.395
R5949 EAOUT.n335 EAOUT.n395 0.8765
R5950 EAOUT.n335 EAOUT.n396 7.3005
R5951 EAOUT.n395 EAOUT.t188 30.395
R5952 EAOUT.n394 EAOUT.n336 5.4025
R5953 EAOUT.n336 EAOUT.n395 2.7745
R5954 EAOUT.n394 EAOUT.t189 30.395
R5955 EAOUT.n393 EAOUT.n394 8.1765
R5956 EAOUT.n393 EAOUT.t190 30.395
R5957 EAOUT.n392 EAOUT.n337 2.7745
R5958 EAOUT.n337 EAOUT.n393 5.4025
R5959 EAOUT.n392 EAOUT.t191 30.395
R5960 EAOUT.n391 EAOUT.n338 7.3005
R5961 EAOUT.n338 EAOUT.n392 0.8765
R5962 EAOUT.n391 EAOUT.t192 30.395
R5963 EAOUT.n339 EAOUT.n390 0.1465
R5964 EAOUT.n339 EAOUT.n391 8.0305
R5965 EAOUT.n390 EAOUT.t193 30.395
R5966 EAOUT.n389 EAOUT.n340 4.6725
R5967 EAOUT.n340 EAOUT.n390 3.5045
R5968 EAOUT.n389 EAOUT.t194 30.395
R5969 EAOUT.n388 EAOUT.n389 8.1765
R5970 EAOUT.n388 EAOUT.t195 30.395
R5971 EAOUT.n387 EAOUT.n341 2.0445
R5972 EAOUT.n341 EAOUT.n388 6.1325
R5973 EAOUT.n387 EAOUT.t196 30.395
R5974 EAOUT.n386 EAOUT.n342 6.5705
R5975 EAOUT.n342 EAOUT.n387 1.6065
R5976 EAOUT.n386 EAOUT.t197 30.395
R5977 EAOUT.n385 EAOUT.n386 8.1765
R5978 EAOUT.n385 EAOUT.t198 30.395
R5979 EAOUT.n384 EAOUT.n343 3.9425
R5980 EAOUT.n343 EAOUT.n385 4.2345
R5981 EAOUT.n384 EAOUT.t199 30.395
R5982 EAOUT.n383 EAOUT.n384 8.1765
R5983 EAOUT.n383 EAOUT.t200 30.395
R5984 EAOUT.n344 EAOUT.n382 1.3145
R5985 EAOUT.n344 EAOUT.n383 6.8625
R5986 EAOUT.n382 EAOUT.t201 30.395
R5987 EAOUT.n381 EAOUT.n345 5.8405
R5988 EAOUT.n345 EAOUT.n382 2.3365
R5989 EAOUT.n381 EAOUT.t202 30.395
R5990 EAOUT.n380 EAOUT.n381 8.1765
R5991 EAOUT.n380 EAOUT.t203 30.395
R5992 EAOUT.n379 EAOUT.n346 3.2125
R5993 EAOUT.n346 EAOUT.n380 4.9645
R5994 EAOUT.n379 EAOUT.t204 30.395
R5995 EAOUT.n378 EAOUT.n347 7.7385
R5996 EAOUT.n347 EAOUT.n379 0.4385
R5997 EAOUT.n378 EAOUT.t205 30.395
R5998 EAOUT.n348 EAOUT.n377 0.5845
R5999 EAOUT.n348 EAOUT.n378 7.5925
R6000 EAOUT.n377 EAOUT.t206 30.395
R6001 EAOUT.n376 EAOUT.n349 5.1105
R6002 EAOUT.n349 EAOUT.n377 3.0665
R6003 EAOUT.n376 EAOUT.t207 30.395
R6004 EAOUT.n375 EAOUT.n376 8.1765
R6005 EAOUT.n375 EAOUT.t208 30.395
R6006 EAOUT.n374 EAOUT.n350 2.4825
R6007 EAOUT.n350 EAOUT.n375 5.6945
R6008 EAOUT.n374 EAOUT.t209 30.395
R6009 EAOUT.n373 EAOUT.n351 7.0085
R6010 EAOUT.n351 EAOUT.n374 1.1685
R6011 EAOUT.n373 EAOUT.t210 30.395
R6012 EAOUT.n372 EAOUT.n373 8.1765
R6013 EAOUT.n372 EAOUT.t211 30.395
R6014 EAOUT.n371 EAOUT.n352 4.3805
R6015 EAOUT.n352 EAOUT.n372 3.7965
R6016 EAOUT.n371 EAOUT.t212 30.395
R6017 EAOUT.n370 EAOUT.n371 8.1765
R6018 EAOUT.n370 EAOUT.t213 30.395
R6019 EAOUT.n353 EAOUT.n369 1.7525
R6020 EAOUT.n353 EAOUT.n370 6.4245
R6021 EAOUT.n369 EAOUT.t214 30.395
R6022 EAOUT.n368 EAOUT.n354 6.2785
R6023 EAOUT.n354 EAOUT.n369 1.8985
R6024 EAOUT.n368 EAOUT.t215 30.395
R6025 EAOUT.n367 EAOUT.n368 8.1765
R6026 EAOUT.n367 EAOUT.t216 30.395
R6027 EAOUT.n366 EAOUT.n355 3.6505
R6028 EAOUT.n355 EAOUT.n367 4.5265
R6029 EAOUT.n366 EAOUT.t217 30.395
R6030 EAOUT.n365 EAOUT.n366 8.1765
R6031 EAOUT.n365 EAOUT.t218 30.395
R6032 EAOUT.n356 EAOUT.n364 1.0225
R6033 EAOUT.n356 EAOUT.n365 7.1545
R6034 EAOUT.n364 EAOUT.t219 30.395
R6035 EAOUT.n363 EAOUT.n357 5.5485
R6036 EAOUT.n357 EAOUT.n364 2.6285
R6037 EAOUT.n363 EAOUT.t220 30.395
R6038 EAOUT.n362 EAOUT.n363 8.1765
R6039 EAOUT.n362 EAOUT.t221 30.395
R6040 EAOUT.n361 EAOUT.n358 2.9205
R6041 EAOUT.n358 EAOUT.n362 5.2565
R6042 EAOUT.n361 EAOUT.t222 30.395
R6043 EAOUT.n360 EAOUT.n359 7.4465
R6044 EAOUT.n359 EAOUT.n361 0.7305
R6045 EAOUT.n360 EAOUT.t223 30.395
R6046 EAOUT.n220 EAOUT.t224 33.7058
R6047 EAOUT.n104 EAOUT.t84 33.7058
R6048 EAOUT.n219 EAOUT.t83 30.395
R6049 EAOUT.n219 EAOUT.n105 7.4465
R6050 EAOUT.n105 EAOUT.n218 0.7305
R6051 EAOUT.n218 EAOUT.t82 30.395
R6052 EAOUT.n218 EAOUT.n106 2.9205
R6053 EAOUT.n106 EAOUT.n217 5.2565
R6054 EAOUT.n217 EAOUT.t81 30.395
R6055 EAOUT.n217 EAOUT.n216 8.1765
R6056 EAOUT.n216 EAOUT.t80 30.395
R6057 EAOUT.n216 EAOUT.n107 5.5485
R6058 EAOUT.n107 EAOUT.n215 2.6285
R6059 EAOUT.n215 EAOUT.t79 30.395
R6060 EAOUT.n108 EAOUT.n215 1.0225
R6061 EAOUT.n108 EAOUT.n214 7.1545
R6062 EAOUT.n214 EAOUT.t78 30.395
R6063 EAOUT.n214 EAOUT.n213 8.1765
R6064 EAOUT.n213 EAOUT.t77 30.395
R6065 EAOUT.n213 EAOUT.n109 3.6505
R6066 EAOUT.n109 EAOUT.n212 4.5265
R6067 EAOUT.n212 EAOUT.t76 30.395
R6068 EAOUT.n212 EAOUT.n211 8.1765
R6069 EAOUT.n211 EAOUT.t75 30.395
R6070 EAOUT.n211 EAOUT.n110 6.2785
R6071 EAOUT.n110 EAOUT.n210 1.8985
R6072 EAOUT.n210 EAOUT.t74 30.395
R6073 EAOUT.n111 EAOUT.n210 1.7525
R6074 EAOUT.n111 EAOUT.n209 6.4245
R6075 EAOUT.n209 EAOUT.t73 30.395
R6076 EAOUT.n209 EAOUT.n208 8.1765
R6077 EAOUT.n208 EAOUT.t72 30.395
R6078 EAOUT.n208 EAOUT.n112 4.3805
R6079 EAOUT.n112 EAOUT.n207 3.7965
R6080 EAOUT.n207 EAOUT.t71 30.395
R6081 EAOUT.n207 EAOUT.n206 8.1765
R6082 EAOUT.n206 EAOUT.t70 30.395
R6083 EAOUT.n206 EAOUT.n113 7.0085
R6084 EAOUT.n113 EAOUT.n205 1.1685
R6085 EAOUT.n205 EAOUT.t69 30.395
R6086 EAOUT.n205 EAOUT.n114 2.4825
R6087 EAOUT.n114 EAOUT.n204 5.6945
R6088 EAOUT.n204 EAOUT.t68 30.395
R6089 EAOUT.n204 EAOUT.n203 8.1765
R6090 EAOUT.n203 EAOUT.t67 30.395
R6091 EAOUT.n203 EAOUT.n115 5.1105
R6092 EAOUT.n115 EAOUT.n202 3.0665
R6093 EAOUT.n202 EAOUT.t66 30.395
R6094 EAOUT.n116 EAOUT.n202 0.5845
R6095 EAOUT.n116 EAOUT.n201 7.5925
R6096 EAOUT.n201 EAOUT.t65 30.395
R6097 EAOUT.n201 EAOUT.n117 7.7385
R6098 EAOUT.n117 EAOUT.n200 0.4385
R6099 EAOUT.n200 EAOUT.t64 30.395
R6100 EAOUT.n200 EAOUT.n118 3.2125
R6101 EAOUT.n118 EAOUT.n199 4.9645
R6102 EAOUT.n199 EAOUT.t63 30.395
R6103 EAOUT.n199 EAOUT.n198 8.1765
R6104 EAOUT.n198 EAOUT.t62 30.395
R6105 EAOUT.n198 EAOUT.n119 5.8405
R6106 EAOUT.n119 EAOUT.n197 2.3365
R6107 EAOUT.n197 EAOUT.t61 30.395
R6108 EAOUT.n120 EAOUT.n197 1.3145
R6109 EAOUT.n120 EAOUT.n196 6.8625
R6110 EAOUT.n196 EAOUT.t60 30.395
R6111 EAOUT.n196 EAOUT.n195 8.1765
R6112 EAOUT.n195 EAOUT.t59 30.395
R6113 EAOUT.n195 EAOUT.n121 3.9425
R6114 EAOUT.n121 EAOUT.n194 4.2345
R6115 EAOUT.n194 EAOUT.t58 30.395
R6116 EAOUT.n194 EAOUT.n193 8.1765
R6117 EAOUT.n193 EAOUT.t57 30.395
R6118 EAOUT.n193 EAOUT.n122 6.5705
R6119 EAOUT.n122 EAOUT.n192 1.6065
R6120 EAOUT.n192 EAOUT.t56 30.395
R6121 EAOUT.n192 EAOUT.n123 2.0445
R6122 EAOUT.n123 EAOUT.n191 6.1325
R6123 EAOUT.n191 EAOUT.t55 30.395
R6124 EAOUT.n191 EAOUT.n190 8.1765
R6125 EAOUT.n190 EAOUT.t54 30.395
R6126 EAOUT.n190 EAOUT.n124 4.6725
R6127 EAOUT.n124 EAOUT.n189 3.5045
R6128 EAOUT.n189 EAOUT.t53 30.395
R6129 EAOUT.n125 EAOUT.n189 0.1465
R6130 EAOUT.n125 EAOUT.n188 8.0305
R6131 EAOUT.n188 EAOUT.t52 30.395
R6132 EAOUT.n188 EAOUT.n126 7.3005
R6133 EAOUT.n126 EAOUT.n187 0.8765
R6134 EAOUT.n187 EAOUT.t51 30.395
R6135 EAOUT.n187 EAOUT.n127 2.7745
R6136 EAOUT.n127 EAOUT.n186 5.4025
R6137 EAOUT.n186 EAOUT.t50 30.395
R6138 EAOUT.n186 EAOUT.n185 8.1765
R6139 EAOUT.n185 EAOUT.t49 30.395
R6140 EAOUT.n185 EAOUT.n128 5.4025
R6141 EAOUT.n128 EAOUT.n184 2.7745
R6142 EAOUT.n184 EAOUT.t48 30.395
R6143 EAOUT.n129 EAOUT.n184 0.8765
R6144 EAOUT.n129 EAOUT.n183 7.3005
R6145 EAOUT.n183 EAOUT.t47 30.395
R6146 EAOUT.n183 EAOUT.n130 8.0305
R6147 EAOUT.n130 EAOUT.n182 0.1465
R6148 EAOUT.n182 EAOUT.t46 30.395
R6149 EAOUT.n182 EAOUT.n131 3.5045
R6150 EAOUT.n131 EAOUT.n181 4.6725
R6151 EAOUT.n181 EAOUT.t45 30.395
R6152 EAOUT.n181 EAOUT.n180 8.1765
R6153 EAOUT.n180 EAOUT.t44 30.395
R6154 EAOUT.n180 EAOUT.n132 6.1325
R6155 EAOUT.n132 EAOUT.n179 2.0445
R6156 EAOUT.n179 EAOUT.t43 30.395
R6157 EAOUT.n133 EAOUT.n179 1.6065
R6158 EAOUT.n133 EAOUT.n178 6.5705
R6159 EAOUT.n178 EAOUT.t42 30.395
R6160 EAOUT.n178 EAOUT.n177 8.1765
R6161 EAOUT.n177 EAOUT.t41 30.395
R6162 EAOUT.n177 EAOUT.n134 4.2345
R6163 EAOUT.n134 EAOUT.n176 3.9425
R6164 EAOUT.n176 EAOUT.t40 30.395
R6165 EAOUT.n176 EAOUT.n175 8.1765
R6166 EAOUT.n175 EAOUT.t39 30.395
R6167 EAOUT.n175 EAOUT.n135 6.8625
R6168 EAOUT.n135 EAOUT.n174 1.3145
R6169 EAOUT.n174 EAOUT.t38 30.395
R6170 EAOUT.n174 EAOUT.n136 2.3365
R6171 EAOUT.n136 EAOUT.n173 5.8405
R6172 EAOUT.n173 EAOUT.t37 30.395
R6173 EAOUT.n173 EAOUT.n172 8.1765
R6174 EAOUT.n172 EAOUT.t36 30.395
R6175 EAOUT.n172 EAOUT.n137 4.9645
R6176 EAOUT.n137 EAOUT.n171 3.2125
R6177 EAOUT.n171 EAOUT.t35 30.395
R6178 EAOUT.n138 EAOUT.n171 0.4385
R6179 EAOUT.n138 EAOUT.n170 7.7385
R6180 EAOUT.n170 EAOUT.t34 30.395
R6181 EAOUT.n170 EAOUT.n139 7.5925
R6182 EAOUT.n139 EAOUT.n169 0.5845
R6183 EAOUT.n169 EAOUT.t33 30.395
R6184 EAOUT.n169 EAOUT.n140 3.0665
R6185 EAOUT.n140 EAOUT.n168 5.1105
R6186 EAOUT.n168 EAOUT.t32 30.395
R6187 EAOUT.n168 EAOUT.n167 8.1765
R6188 EAOUT.n167 EAOUT.t31 30.395
R6189 EAOUT.n167 EAOUT.n141 5.6945
R6190 EAOUT.n141 EAOUT.n166 2.4825
R6191 EAOUT.n166 EAOUT.t30 30.395
R6192 EAOUT.n142 EAOUT.n166 1.1685
R6193 EAOUT.n142 EAOUT.n165 7.0085
R6194 EAOUT.n165 EAOUT.t29 30.395
R6195 EAOUT.n165 EAOUT.n164 8.1765
R6196 EAOUT.n164 EAOUT.t28 30.395
R6197 EAOUT.n164 EAOUT.n143 3.7965
R6198 EAOUT.n143 EAOUT.n163 4.3805
R6199 EAOUT.n163 EAOUT.t27 30.395
R6200 EAOUT.n163 EAOUT.n162 8.1765
R6201 EAOUT.n162 EAOUT.t26 30.395
R6202 EAOUT.n162 EAOUT.n144 6.4245
R6203 EAOUT.n144 EAOUT.n161 1.7525
R6204 EAOUT.n161 EAOUT.t25 30.395
R6205 EAOUT.n161 EAOUT.n145 1.8985
R6206 EAOUT.n145 EAOUT.n160 6.2785
R6207 EAOUT.n160 EAOUT.t24 30.395
R6208 EAOUT.n160 EAOUT.n159 8.1765
R6209 EAOUT.n159 EAOUT.t23 30.395
R6210 EAOUT.n159 EAOUT.n146 4.5265
R6211 EAOUT.n146 EAOUT.n147 3.6505
R6212 EAOUT.n147 EAOUT.t22 30.395
R6213 EAOUT.n147 EAOUT.n158 8.1765
R6214 EAOUT.n158 EAOUT.t21 30.395
R6215 EAOUT.n158 EAOUT.n148 7.1545
R6216 EAOUT.n148 EAOUT.n157 1.0225
R6217 EAOUT.n157 EAOUT.t20 30.395
R6218 EAOUT.n157 EAOUT.n149 2.6285
R6219 EAOUT.n149 EAOUT.n156 5.5485
R6220 EAOUT.n156 EAOUT.t19 30.395
R6221 EAOUT.n156 EAOUT.n155 8.1765
R6222 EAOUT.n155 EAOUT.t18 30.395
R6223 EAOUT.n155 EAOUT.n150 5.2565
R6224 EAOUT.n150 EAOUT.n154 2.9205
R6225 EAOUT.n154 EAOUT.t17 30.395
R6226 EAOUT.n151 EAOUT.n154 0.7305
R6227 EAOUT.n151 EAOUT.n153 7.4465
R6228 EAOUT.n153 EAOUT.t16 30.395
R6229 EAOUT.n153 EAOUT.n152 7.8845
R6230 EAOUT.n152 EAOUT.t15 30.687
R6231 EAOUT.t1 EAOUT.n8 11.9646
R6232 EAOUT.n8 EAOUT.n4 1.2821
R6233 EAOUT.n4 EAOUT.n6 1.2821
R6234 EAOUT.n6 EAOUT.n5 0.6413
R6235 EAOUT.n5 EAOUT 8.4731
R6236 EAOUT.n8 EAOUT.n9 10.971
R6237 EAOUT.t2 EAOUT.n9 0.3533
R6238 EAOUT.n9 EAOUT.t5 0.3533
R6239 EAOUT.n6 EAOUT.n7 10.971
R6240 EAOUT.t6 EAOUT.n7 0.3533
R6241 EAOUT.n7 EAOUT.t3 0.3533
R6242 EAOUT.n5 EAOUT.t4 11.3238
R6243 EAOUT.n3 EAOUT.n4 6.21311
R6244 EAOUT.t7 EAOUT.n3 0.3533
R6245 EAOUT.n3 EAOUT.t8 0.3533
R6246 EAOUT.n2 EAOUT.n1 11.0622
R6247 EAOUT.n1 EAOUT.t11 1.5685
R6248 EAOUT.n1 EAOUT.t12 1.5685
R6249 EAOUT.n2 EAOUT.n0 11.4618
R6250 EAOUT.n0 EAOUT.t9 1.5685
R6251 EAOUT.n0 EAOUT.t10 1.5685
R6252 VIN_BIAS.n0 VIN_BIAS.t1 0.3925
R6253 VIN_BIAS.n0 VIN_BIAS.t2 0.3925
R6254 VIN_BIAS VIN_BIAS.n0 14.5897
R6255 VIN_BIAS.t0 VIN_BIAS.n1 82.3099
R6256 VIN_BIAS.n1 VIN_BIAS 8.90576
R6257 VIN_BIAS.n1 VIN_BIAS.t3 26.4682
R6258 a_644_5248.t3 a_644_5248.n0 8.69666
R6259 a_644_5248.n0 a_644_5248.n7 10.8232
R6260 a_644_5248.n7 a_644_5248.n1 1.72471
R6261 a_644_5248.n7 a_644_5248.t5 28.2003
R6262 a_644_5248.n1 a_644_5248.n6 22.9339
R6263 a_644_5248.n3 a_644_5248.n2 4.5005
R6264 a_644_5248.n6 a_644_5248.n3 0.261026
R6265 a_644_5248.n6 a_644_5248.n5 5.3789
R6266 a_644_5248.n5 a_644_5248.t7 64.0872
R6267 a_644_5248.n5 a_644_5248.t8 64.5444
R6268 a_644_5248.n3 a_644_5248.n4 5.18223
R6269 a_644_5248.n4 a_644_5248.t2 37.3205
R6270 a_644_5248.n4 a_644_5248.t0 38.6921
R6271 a_644_5248.n2 a_644_5248.t6 50.7398
R6272 a_644_5248.n2 a_644_5248.t9 52.9538
R6273 a_644_5248.n1 a_644_5248.t4 21.8213
R6274 a_644_5248.n0 a_644_5248.t1 7.32506
C73 EN VSS 5.1513f
C74 VREF VSS 15.00815f
C75 FB_BUF VSS 7.92164f
C76 EAOUT_BUF VSS 7.32966f
C77 VOUT VSS 29.36194f
C78 VIN VSS 0.48248p
C79 IREF VSS 16.83689f ; **FLOATING
C80 v2_pmos_core.EN_5V VSS 11.12373f ; **FLOATING
C81 v2_pmos_core.EAREF VSS 6.86843f ; **FLOATING
C82 v2_pmos_core.ENB_5V VSS 13.9042f ; **FLOATING
C83 EAOUT VSS 28.27039f ; **FLOATING
C84 a_16652_8722# VSS 1.40196f ; **FLOATING
C85 a_15692_18710# VSS 1.45777f ; **FLOATING
C86 a_15212_18710# VSS 1.38361f ; **FLOATING
C87 a_14732_8722# VSS 1.47046f ; **FLOATING
C88 a_14252_8722# VSS 1.37773f ; **FLOATING
C89 a_13772_18710# VSS 1.47358f ; **FLOATING
C90 a_13292_18710# VSS 1.37661f ; **FLOATING
C91 a_12812_8722# VSS 1.72453f ; **FLOATING
C92 FB VSS 17.4028f ; **FLOATING
C93 a_12332_18710# VSS 1.40397f ; **FLOATING
C94 VIN_BIAS VSS 24.78925f ; **FLOATING
C95 a_644_5248.t3 VSS 0.21614f ; **FLOATING
C96 a_644_5248.t1 VSS 0.1842f ; **FLOATING
C97 a_644_5248.n0 VSS 0.39989f ; **FLOATING
C98 a_644_5248.t4 VSS 0.05054f ; **FLOATING
C99 a_644_5248.n1 VSS 0.41646f ; **FLOATING
C100 a_644_5248.t9 VSS 0.09499f ; **FLOATING
C101 a_644_5248.t6 VSS 0.08729f ; **FLOATING
C102 a_644_5248.n2 VSS 0.36081f ; **FLOATING
C103 a_644_5248.n3 VSS 0.02915f ; **FLOATING
C104 a_644_5248.t0 VSS 0.08942f ; **FLOATING
C105 a_644_5248.t2 VSS 0.08454f ; **FLOATING
C106 a_644_5248.n4 VSS 0.31788f ; **FLOATING
C107 a_644_5248.t8 VSS 0.09588f ; **FLOATING
C108 a_644_5248.t7 VSS 0.09529f ; **FLOATING
C109 a_644_5248.n5 VSS 0.2559f ; **FLOATING
C110 a_644_5248.n6 VSS 0.32756f ; **FLOATING
C111 a_644_5248.t5 VSS 0.15111f ; **FLOATING
C112 a_644_5248.n7 VSS 0.47967f ; **FLOATING
C113 VIN_BIAS.t2 VSS 0.08074f ; **FLOATING
C114 VIN_BIAS.n0 VSS 1.16251f ; **FLOATING
C115 VIN_BIAS.t0 VSS 2.47245f ; **FLOATING
C116 VIN_BIAS.n1 VSS 6.18462f ; **FLOATING
C117 VIN_BIAS.t3 VSS 0.17443f ; **FLOATING
C118 VIN_BIAS.t1 VSS 0.08074f ; **FLOATING
C119 EAOUT.t0 VSS 0.42366f ; **FLOATING
C120 EAOUT.t9 VSS 0.00859f ; **FLOATING
C121 EAOUT.t10 VSS 0.00859f ; **FLOATING
C122 EAOUT.n0 VSS 0.12313f ; **FLOATING
C123 EAOUT.t11 VSS 0.00859f ; **FLOATING
C124 EAOUT.t12 VSS 0.00859f ; **FLOATING
C125 EAOUT.n1 VSS 0.11815f ; **FLOATING
C126 EAOUT.n2 VSS 0.49558f ; **FLOATING
C127 EAOUT.t7 VSS 0.03436f ; **FLOATING
C128 EAOUT.t8 VSS 0.03436f ; **FLOATING
C129 EAOUT.n3 VSS 0.33558f ; **FLOATING
C130 EAOUT.n4 VSS 0.22284f ; **FLOATING
C131 EAOUT.n5 VSS 0.39883f ; **FLOATING
C132 EAOUT.t4 VSS 0.39093f ; **FLOATING
C133 EAOUT.n6 VSS 0.18136f ; **FLOATING
C134 EAOUT.t6 VSS 0.03436f ; **FLOATING
C135 EAOUT.t3 VSS 0.03436f ; **FLOATING
C136 EAOUT.n7 VSS 0.32386f ; **FLOATING
C137 EAOUT.n8 VSS 0.28697f ; **FLOATING
C138 EAOUT.t2 VSS 0.03436f ; **FLOATING
C139 EAOUT.t5 VSS 0.03436f ; **FLOATING
C140 EAOUT.n9 VSS 0.32386f ; **FLOATING
C141 EAOUT.t1 VSS 0.3969f ; **FLOATING
C142 EAOUT.n10 VSS 0.07321f ; **FLOATING
C143 EAOUT.n11 VSS 0.02749f ; **FLOATING
C144 EAOUT.n12 VSS 0.02749f ; **FLOATING
C145 EAOUT.n13 VSS 0.02749f ; **FLOATING
C146 EAOUT.n14 VSS 0.02749f ; **FLOATING
C147 EAOUT.n15 VSS 0.02749f ; **FLOATING
C148 EAOUT.n16 VSS 0.02749f ; **FLOATING
C149 EAOUT.n17 VSS 0.02749f ; **FLOATING
C150 EAOUT.n18 VSS 0.02749f ; **FLOATING
C151 EAOUT.n19 VSS 0.02749f ; **FLOATING
C152 EAOUT.n20 VSS 0.02749f ; **FLOATING
C153 EAOUT.n21 VSS 0.02749f ; **FLOATING
C154 EAOUT.n22 VSS 0.02749f ; **FLOATING
C155 EAOUT.n23 VSS 0.02749f ; **FLOATING
C156 EAOUT.n24 VSS 0.02749f ; **FLOATING
C157 EAOUT.n25 VSS 0.02749f ; **FLOATING
C158 EAOUT.n26 VSS 0.02749f ; **FLOATING
C159 EAOUT.n27 VSS 0.02749f ; **FLOATING
C160 EAOUT.n28 VSS 0.02749f ; **FLOATING
C161 EAOUT.n29 VSS 0.02749f ; **FLOATING
C162 EAOUT.n30 VSS 0.02749f ; **FLOATING
C163 EAOUT.n31 VSS 0.02749f ; **FLOATING
C164 EAOUT.n32 VSS 0.02749f ; **FLOATING
C165 EAOUT.n33 VSS 0.02749f ; **FLOATING
C166 EAOUT.n34 VSS 0.02749f ; **FLOATING
C167 EAOUT.n35 VSS 0.02749f ; **FLOATING
C168 EAOUT.n36 VSS 0.02749f ; **FLOATING
C169 EAOUT.n37 VSS 0.02749f ; **FLOATING
C170 EAOUT.n38 VSS 0.02749f ; **FLOATING
C171 EAOUT.n39 VSS 0.02749f ; **FLOATING
C172 EAOUT.n40 VSS 0.02749f ; **FLOATING
C173 EAOUT.n41 VSS 0.02749f ; **FLOATING
C174 EAOUT.n42 VSS 0.02749f ; **FLOATING
C175 EAOUT.n43 VSS 0.02749f ; **FLOATING
C176 EAOUT.n44 VSS 0.02749f ; **FLOATING
C177 EAOUT.n45 VSS 0.02749f ; **FLOATING
C178 EAOUT.n46 VSS 0.02749f ; **FLOATING
C179 EAOUT.n47 VSS 0.02209f ; **FLOATING
C180 EAOUT.n48 VSS 0.02307f ; **FLOATING
C181 EAOUT.n49 VSS 0.02749f ; **FLOATING
C182 EAOUT.n50 VSS 0.02749f ; **FLOATING
C183 EAOUT.n51 VSS 0.02749f ; **FLOATING
C184 EAOUT.n52 VSS 0.02749f ; **FLOATING
C185 EAOUT.n53 VSS 0.02749f ; **FLOATING
C186 EAOUT.n54 VSS 0.02749f ; **FLOATING
C187 EAOUT.n55 VSS 0.02749f ; **FLOATING
C188 EAOUT.n56 VSS 0.02749f ; **FLOATING
C189 EAOUT.n57 VSS 0.02749f ; **FLOATING
C190 EAOUT.n58 VSS 0.02749f ; **FLOATING
C191 EAOUT.n59 VSS 0.02749f ; **FLOATING
C192 EAOUT.n60 VSS 0.02749f ; **FLOATING
C193 EAOUT.n61 VSS 0.02749f ; **FLOATING
C194 EAOUT.n62 VSS 0.02749f ; **FLOATING
C195 EAOUT.n63 VSS 0.02749f ; **FLOATING
C196 EAOUT.n64 VSS 0.02749f ; **FLOATING
C197 EAOUT.n65 VSS 0.02749f ; **FLOATING
C198 EAOUT.n66 VSS 0.02749f ; **FLOATING
C199 EAOUT.n67 VSS 0.02749f ; **FLOATING
C200 EAOUT.n68 VSS 0.02749f ; **FLOATING
C201 EAOUT.n69 VSS 0.02749f ; **FLOATING
C202 EAOUT.n70 VSS 0.02749f ; **FLOATING
C203 EAOUT.n71 VSS 0.02749f ; **FLOATING
C204 EAOUT.n72 VSS 0.02749f ; **FLOATING
C205 EAOUT.n73 VSS 0.02749f ; **FLOATING
C206 EAOUT.n74 VSS 0.02749f ; **FLOATING
C207 EAOUT.n75 VSS 0.02749f ; **FLOATING
C208 EAOUT.n76 VSS 0.02749f ; **FLOATING
C209 EAOUT.n77 VSS 0.02749f ; **FLOATING
C210 EAOUT.n78 VSS 0.02749f ; **FLOATING
C211 EAOUT.n79 VSS 0.02749f ; **FLOATING
C212 EAOUT.n80 VSS 0.02749f ; **FLOATING
C213 EAOUT.n81 VSS 0.02749f ; **FLOATING
C214 EAOUT.n82 VSS 0.02749f ; **FLOATING
C215 EAOUT.n83 VSS 0.02749f ; **FLOATING
C216 EAOUT.n84 VSS 0.02749f ; **FLOATING
C217 EAOUT.n85 VSS 0.02749f ; **FLOATING
C218 EAOUT.n86 VSS 0.02749f ; **FLOATING
C219 EAOUT.n87 VSS 0.02749f ; **FLOATING
C220 EAOUT.n88 VSS 0.02749f ; **FLOATING
C221 EAOUT.n89 VSS 0.02749f ; **FLOATING
C222 EAOUT.n90 VSS 0.02749f ; **FLOATING
C223 EAOUT.n91 VSS 0.02749f ; **FLOATING
C224 EAOUT.n92 VSS 0.02749f ; **FLOATING
C225 EAOUT.n93 VSS 0.02749f ; **FLOATING
C226 EAOUT.n94 VSS 0.02749f ; **FLOATING
C227 EAOUT.n95 VSS 0.02749f ; **FLOATING
C228 EAOUT.n96 VSS 0.02749f ; **FLOATING
C229 EAOUT.n97 VSS 0.02749f ; **FLOATING
C230 EAOUT.n98 VSS 0.02749f ; **FLOATING
C231 EAOUT.n99 VSS 0.02749f ; **FLOATING
C232 EAOUT.n100 VSS 0.02749f ; **FLOATING
C233 EAOUT.n101 VSS 0.02749f ; **FLOATING
C234 EAOUT.n102 VSS 0.02749f ; **FLOATING
C235 EAOUT.n103 VSS 0.08456f ; **FLOATING
C236 EAOUT.n104 VSS 0.04651f ; **FLOATING
C237 EAOUT.t84 VSS 0.08265f ; **FLOATING
C238 EAOUT.n105 VSS 0.01129f ; **FLOATING
C239 EAOUT.n106 VSS 0.01129f ; **FLOATING
C240 EAOUT.n107 VSS 0.01129f ; **FLOATING
C241 EAOUT.n108 VSS 0.01129f ; **FLOATING
C242 EAOUT.n109 VSS 0.01129f ; **FLOATING
C243 EAOUT.n110 VSS 0.01129f ; **FLOATING
C244 EAOUT.n111 VSS 0.01129f ; **FLOATING
C245 EAOUT.n112 VSS 0.01129f ; **FLOATING
C246 EAOUT.n113 VSS 0.01129f ; **FLOATING
C247 EAOUT.n114 VSS 0.01129f ; **FLOATING
C248 EAOUT.n115 VSS 0.01129f ; **FLOATING
C249 EAOUT.n116 VSS 0.01129f ; **FLOATING
C250 EAOUT.n117 VSS 0.01129f ; **FLOATING
C251 EAOUT.n118 VSS 0.01129f ; **FLOATING
C252 EAOUT.n119 VSS 0.01129f ; **FLOATING
C253 EAOUT.n120 VSS 0.01129f ; **FLOATING
C254 EAOUT.n121 VSS 0.01129f ; **FLOATING
C255 EAOUT.n122 VSS 0.01129f ; **FLOATING
C256 EAOUT.n123 VSS 0.01129f ; **FLOATING
C257 EAOUT.n124 VSS 0.01129f ; **FLOATING
C258 EAOUT.n125 VSS 0.01129f ; **FLOATING
C259 EAOUT.n126 VSS 0.01129f ; **FLOATING
C260 EAOUT.n127 VSS 0.01129f ; **FLOATING
C261 EAOUT.n128 VSS 0.01129f ; **FLOATING
C262 EAOUT.n129 VSS 0.01129f ; **FLOATING
C263 EAOUT.n130 VSS 0.01129f ; **FLOATING
C264 EAOUT.n131 VSS 0.01129f ; **FLOATING
C265 EAOUT.n132 VSS 0.01129f ; **FLOATING
C266 EAOUT.n133 VSS 0.01129f ; **FLOATING
C267 EAOUT.n134 VSS 0.01129f ; **FLOATING
C268 EAOUT.n135 VSS 0.01129f ; **FLOATING
C269 EAOUT.n136 VSS 0.01129f ; **FLOATING
C270 EAOUT.n137 VSS 0.01129f ; **FLOATING
C271 EAOUT.n138 VSS 0.01129f ; **FLOATING
C272 EAOUT.n139 VSS 0.01129f ; **FLOATING
C273 EAOUT.n140 VSS 0.01129f ; **FLOATING
C274 EAOUT.n141 VSS 0.01129f ; **FLOATING
C275 EAOUT.n142 VSS 0.01129f ; **FLOATING
C276 EAOUT.n143 VSS 0.01129f ; **FLOATING
C277 EAOUT.n144 VSS 0.01129f ; **FLOATING
C278 EAOUT.n145 VSS 0.01129f ; **FLOATING
C279 EAOUT.n146 VSS 0.01129f ; **FLOATING
C280 EAOUT.n147 VSS 0.05202f ; **FLOATING
C281 EAOUT.n148 VSS 0.01129f ; **FLOATING
C282 EAOUT.n149 VSS 0.01129f ; **FLOATING
C283 EAOUT.n150 VSS 0.01129f ; **FLOATING
C284 EAOUT.n151 VSS 0.01129f ; **FLOATING
C285 EAOUT.n152 VSS 0.04883f ; **FLOATING
C286 EAOUT.t15 VSS 0.07824f ; **FLOATING
C287 EAOUT.n153 VSS 0.05496f ; **FLOATING
C288 EAOUT.t16 VSS 0.07788f ; **FLOATING
C289 EAOUT.n154 VSS 0.04073f ; **FLOATING
C290 EAOUT.t17 VSS 0.07788f ; **FLOATING
C291 EAOUT.n155 VSS 0.05337f ; **FLOATING
C292 EAOUT.t18 VSS 0.07788f ; **FLOATING
C293 EAOUT.n156 VSS 0.05361f ; **FLOATING
C294 EAOUT.t19 VSS 0.07788f ; **FLOATING
C295 EAOUT.n157 VSS 0.04073f ; **FLOATING
C296 EAOUT.t20 VSS 0.07788f ; **FLOATING
C297 EAOUT.n158 VSS 0.05496f ; **FLOATING
C298 EAOUT.t21 VSS 0.07788f ; **FLOATING
C299 EAOUT.t22 VSS 0.07788f ; **FLOATING
C300 EAOUT.n159 VSS 0.05275f ; **FLOATING
C301 EAOUT.t23 VSS 0.07788f ; **FLOATING
C302 EAOUT.n160 VSS 0.05423f ; **FLOATING
C303 EAOUT.t24 VSS 0.07788f ; **FLOATING
C304 EAOUT.n161 VSS 0.04073f ; **FLOATING
C305 EAOUT.t25 VSS 0.07788f ; **FLOATING
C306 EAOUT.n162 VSS 0.05435f ; **FLOATING
C307 EAOUT.t26 VSS 0.07788f ; **FLOATING
C308 EAOUT.n163 VSS 0.05263f ; **FLOATING
C309 EAOUT.t27 VSS 0.07788f ; **FLOATING
C310 EAOUT.n164 VSS 0.05214f ; **FLOATING
C311 EAOUT.t28 VSS 0.07788f ; **FLOATING
C312 EAOUT.n165 VSS 0.05484f ; **FLOATING
C313 EAOUT.t29 VSS 0.07788f ; **FLOATING
C314 EAOUT.n166 VSS 0.04073f ; **FLOATING
C315 EAOUT.t30 VSS 0.07788f ; **FLOATING
C316 EAOUT.n167 VSS 0.05373f ; **FLOATING
C317 EAOUT.t31 VSS 0.07788f ; **FLOATING
C318 EAOUT.n168 VSS 0.05324f ; **FLOATING
C319 EAOUT.t32 VSS 0.07788f ; **FLOATING
C320 EAOUT.n169 VSS 0.04073f ; **FLOATING
C321 EAOUT.t33 VSS 0.07788f ; **FLOATING
C322 EAOUT.n170 VSS 0.05496f ; **FLOATING
C323 EAOUT.t34 VSS 0.07788f ; **FLOATING
C324 EAOUT.n171 VSS 0.04073f ; **FLOATING
C325 EAOUT.t35 VSS 0.07788f ; **FLOATING
C326 EAOUT.n172 VSS 0.05312f ; **FLOATING
C327 EAOUT.t36 VSS 0.07788f ; **FLOATING
C328 EAOUT.n173 VSS 0.05386f ; **FLOATING
C329 EAOUT.t37 VSS 0.07788f ; **FLOATING
C330 EAOUT.n174 VSS 0.04073f ; **FLOATING
C331 EAOUT.t38 VSS 0.07788f ; **FLOATING
C332 EAOUT.n175 VSS 0.05472f ; **FLOATING
C333 EAOUT.t39 VSS 0.07788f ; **FLOATING
C334 EAOUT.n176 VSS 0.05226f ; **FLOATING
C335 EAOUT.t40 VSS 0.07788f ; **FLOATING
C336 EAOUT.n177 VSS 0.05251f ; **FLOATING
C337 EAOUT.t41 VSS 0.07788f ; **FLOATING
C338 EAOUT.n178 VSS 0.05447f ; **FLOATING
C339 EAOUT.t42 VSS 0.07788f ; **FLOATING
C340 EAOUT.n179 VSS 0.04073f ; **FLOATING
C341 EAOUT.t43 VSS 0.07788f ; **FLOATING
C342 EAOUT.n180 VSS 0.0541f ; **FLOATING
C343 EAOUT.t44 VSS 0.07788f ; **FLOATING
C344 EAOUT.n181 VSS 0.05288f ; **FLOATING
C345 EAOUT.t45 VSS 0.07788f ; **FLOATING
C346 EAOUT.n182 VSS 0.04073f ; **FLOATING
C347 EAOUT.t46 VSS 0.07788f ; **FLOATING
C348 EAOUT.n183 VSS 0.05496f ; **FLOATING
C349 EAOUT.t47 VSS 0.07788f ; **FLOATING
C350 EAOUT.n184 VSS 0.04073f ; **FLOATING
C351 EAOUT.t48 VSS 0.07788f ; **FLOATING
C352 EAOUT.n185 VSS 0.05349f ; **FLOATING
C353 EAOUT.t49 VSS 0.07788f ; **FLOATING
C354 EAOUT.n186 VSS 0.05349f ; **FLOATING
C355 EAOUT.t50 VSS 0.07788f ; **FLOATING
C356 EAOUT.n187 VSS 0.04073f ; **FLOATING
C357 EAOUT.t51 VSS 0.07788f ; **FLOATING
C358 EAOUT.n188 VSS 0.05496f ; **FLOATING
C359 EAOUT.t52 VSS 0.07788f ; **FLOATING
C360 EAOUT.n189 VSS 0.04073f ; **FLOATING
C361 EAOUT.t53 VSS 0.07788f ; **FLOATING
C362 EAOUT.n190 VSS 0.05288f ; **FLOATING
C363 EAOUT.t54 VSS 0.07788f ; **FLOATING
C364 EAOUT.n191 VSS 0.0541f ; **FLOATING
C365 EAOUT.t55 VSS 0.07788f ; **FLOATING
C366 EAOUT.n192 VSS 0.04073f ; **FLOATING
C367 EAOUT.t56 VSS 0.07788f ; **FLOATING
C368 EAOUT.n193 VSS 0.05447f ; **FLOATING
C369 EAOUT.t57 VSS 0.07788f ; **FLOATING
C370 EAOUT.n194 VSS 0.05251f ; **FLOATING
C371 EAOUT.t58 VSS 0.07788f ; **FLOATING
C372 EAOUT.n195 VSS 0.05226f ; **FLOATING
C373 EAOUT.t59 VSS 0.07788f ; **FLOATING
C374 EAOUT.n196 VSS 0.05472f ; **FLOATING
C375 EAOUT.t60 VSS 0.07788f ; **FLOATING
C376 EAOUT.n197 VSS 0.04073f ; **FLOATING
C377 EAOUT.t61 VSS 0.07788f ; **FLOATING
C378 EAOUT.n198 VSS 0.05386f ; **FLOATING
C379 EAOUT.t62 VSS 0.07788f ; **FLOATING
C380 EAOUT.n199 VSS 0.05312f ; **FLOATING
C381 EAOUT.t63 VSS 0.07788f ; **FLOATING
C382 EAOUT.n200 VSS 0.04073f ; **FLOATING
C383 EAOUT.t64 VSS 0.07788f ; **FLOATING
C384 EAOUT.n201 VSS 0.05496f ; **FLOATING
C385 EAOUT.t65 VSS 0.07788f ; **FLOATING
C386 EAOUT.n202 VSS 0.04073f ; **FLOATING
C387 EAOUT.t66 VSS 0.07788f ; **FLOATING
C388 EAOUT.n203 VSS 0.05324f ; **FLOATING
C389 EAOUT.t67 VSS 0.07788f ; **FLOATING
C390 EAOUT.n204 VSS 0.05373f ; **FLOATING
C391 EAOUT.t68 VSS 0.07788f ; **FLOATING
C392 EAOUT.n205 VSS 0.04073f ; **FLOATING
C393 EAOUT.t69 VSS 0.07788f ; **FLOATING
C394 EAOUT.n206 VSS 0.05484f ; **FLOATING
C395 EAOUT.t70 VSS 0.07788f ; **FLOATING
C396 EAOUT.n207 VSS 0.05214f ; **FLOATING
C397 EAOUT.t71 VSS 0.07788f ; **FLOATING
C398 EAOUT.n208 VSS 0.05263f ; **FLOATING
C399 EAOUT.t72 VSS 0.07788f ; **FLOATING
C400 EAOUT.n209 VSS 0.05435f ; **FLOATING
C401 EAOUT.t73 VSS 0.07788f ; **FLOATING
C402 EAOUT.n210 VSS 0.04073f ; **FLOATING
C403 EAOUT.t74 VSS 0.07788f ; **FLOATING
C404 EAOUT.n211 VSS 0.05423f ; **FLOATING
C405 EAOUT.t75 VSS 0.07788f ; **FLOATING
C406 EAOUT.n212 VSS 0.05275f ; **FLOATING
C407 EAOUT.t76 VSS 0.07788f ; **FLOATING
C408 EAOUT.n213 VSS 0.05202f ; **FLOATING
C409 EAOUT.t77 VSS 0.07788f ; **FLOATING
C410 EAOUT.n214 VSS 0.05496f ; **FLOATING
C411 EAOUT.t78 VSS 0.07788f ; **FLOATING
C412 EAOUT.n215 VSS 0.04073f ; **FLOATING
C413 EAOUT.t79 VSS 0.07788f ; **FLOATING
C414 EAOUT.n216 VSS 0.05361f ; **FLOATING
C415 EAOUT.t80 VSS 0.07788f ; **FLOATING
C416 EAOUT.n217 VSS 0.05337f ; **FLOATING
C417 EAOUT.t81 VSS 0.07788f ; **FLOATING
C418 EAOUT.n218 VSS 0.04073f ; **FLOATING
C419 EAOUT.t82 VSS 0.07788f ; **FLOATING
C420 EAOUT.n219 VSS 0.05496f ; **FLOATING
C421 EAOUT.t83 VSS 0.07788f ; **FLOATING
C422 EAOUT.n220 VSS 0.04651f ; **FLOATING
C423 EAOUT.n221 VSS 0.08456f ; **FLOATING
C424 EAOUT.n222 VSS 0.02749f ; **FLOATING
C425 EAOUT.n223 VSS 0.02749f ; **FLOATING
C426 EAOUT.n224 VSS 0.02749f ; **FLOATING
C427 EAOUT.n225 VSS 0.02749f ; **FLOATING
C428 EAOUT.n226 VSS 0.02749f ; **FLOATING
C429 EAOUT.n227 VSS 0.02749f ; **FLOATING
C430 EAOUT.n228 VSS 0.02749f ; **FLOATING
C431 EAOUT.n229 VSS 0.02749f ; **FLOATING
C432 EAOUT.n230 VSS 0.02749f ; **FLOATING
C433 EAOUT.n231 VSS 0.02749f ; **FLOATING
C434 EAOUT.n232 VSS 0.02749f ; **FLOATING
C435 EAOUT.n233 VSS 0.02749f ; **FLOATING
C436 EAOUT.n234 VSS 0.02749f ; **FLOATING
C437 EAOUT.n235 VSS 0.02749f ; **FLOATING
C438 EAOUT.n236 VSS 0.02749f ; **FLOATING
C439 EAOUT.n237 VSS 0.02749f ; **FLOATING
C440 EAOUT.n238 VSS 0.02749f ; **FLOATING
C441 EAOUT.n239 VSS 0.02749f ; **FLOATING
C442 EAOUT.n240 VSS 0.02749f ; **FLOATING
C443 EAOUT.n241 VSS 0.02749f ; **FLOATING
C444 EAOUT.n242 VSS 0.02749f ; **FLOATING
C445 EAOUT.n243 VSS 0.02749f ; **FLOATING
C446 EAOUT.n244 VSS 0.02749f ; **FLOATING
C447 EAOUT.n245 VSS 0.02749f ; **FLOATING
C448 EAOUT.n246 VSS 0.02749f ; **FLOATING
C449 EAOUT.n247 VSS 0.02749f ; **FLOATING
C450 EAOUT.n248 VSS 0.02749f ; **FLOATING
C451 EAOUT.n249 VSS 0.02749f ; **FLOATING
C452 EAOUT.n250 VSS 0.02749f ; **FLOATING
C453 EAOUT.n251 VSS 0.02749f ; **FLOATING
C454 EAOUT.n252 VSS 0.02749f ; **FLOATING
C455 EAOUT.n253 VSS 0.02749f ; **FLOATING
C456 EAOUT.n254 VSS 0.02749f ; **FLOATING
C457 EAOUT.n255 VSS 0.02749f ; **FLOATING
C458 EAOUT.n256 VSS 0.02749f ; **FLOATING
C459 EAOUT.n257 VSS 0.02749f ; **FLOATING
C460 EAOUT.n258 VSS 0.02749f ; **FLOATING
C461 EAOUT.n259 VSS 0.02749f ; **FLOATING
C462 EAOUT.n260 VSS 0.02749f ; **FLOATING
C463 EAOUT.n261 VSS 0.02749f ; **FLOATING
C464 EAOUT.n262 VSS 0.02749f ; **FLOATING
C465 EAOUT.n263 VSS 0.02749f ; **FLOATING
C466 EAOUT.n264 VSS 0.02749f ; **FLOATING
C467 EAOUT.n265 VSS 0.02749f ; **FLOATING
C468 EAOUT.n266 VSS 0.02749f ; **FLOATING
C469 EAOUT.n267 VSS 0.02749f ; **FLOATING
C470 EAOUT.n268 VSS 0.02749f ; **FLOATING
C471 EAOUT.n269 VSS 0.02749f ; **FLOATING
C472 EAOUT.n270 VSS 0.02749f ; **FLOATING
C473 EAOUT.n271 VSS 0.02749f ; **FLOATING
C474 EAOUT.n272 VSS 0.02749f ; **FLOATING
C475 EAOUT.n273 VSS 0.02749f ; **FLOATING
C476 EAOUT.n274 VSS 0.02749f ; **FLOATING
C477 EAOUT.n275 VSS 0.02749f ; **FLOATING
C478 EAOUT.n276 VSS 0.02749f ; **FLOATING
C479 EAOUT.n277 VSS 0.02749f ; **FLOATING
C480 EAOUT.n278 VSS 0.02749f ; **FLOATING
C481 EAOUT.n279 VSS 0.02749f ; **FLOATING
C482 EAOUT.n280 VSS 0.02749f ; **FLOATING
C483 EAOUT.n281 VSS 0.02749f ; **FLOATING
C484 EAOUT.n282 VSS 0.02749f ; **FLOATING
C485 EAOUT.n283 VSS 0.02749f ; **FLOATING
C486 EAOUT.n284 VSS 0.02749f ; **FLOATING
C487 EAOUT.n285 VSS 0.02749f ; **FLOATING
C488 EAOUT.n286 VSS 0.02749f ; **FLOATING
C489 EAOUT.n287 VSS 0.02749f ; **FLOATING
C490 EAOUT.n288 VSS 0.02749f ; **FLOATING
C491 EAOUT.n289 VSS 0.02749f ; **FLOATING
C492 EAOUT.n290 VSS 0.02749f ; **FLOATING
C493 EAOUT.n291 VSS 0.02749f ; **FLOATING
C494 EAOUT.n292 VSS 0.02749f ; **FLOATING
C495 EAOUT.n293 VSS 0.02749f ; **FLOATING
C496 EAOUT.n294 VSS 0.02749f ; **FLOATING
C497 EAOUT.n295 VSS 0.02749f ; **FLOATING
C498 EAOUT.n296 VSS 0.02749f ; **FLOATING
C499 EAOUT.n297 VSS 0.02749f ; **FLOATING
C500 EAOUT.n298 VSS 0.02749f ; **FLOATING
C501 EAOUT.n299 VSS 0.02749f ; **FLOATING
C502 EAOUT.n300 VSS 0.02749f ; **FLOATING
C503 EAOUT.n301 VSS 0.02749f ; **FLOATING
C504 EAOUT.n302 VSS 0.02749f ; **FLOATING
C505 EAOUT.n303 VSS 0.02749f ; **FLOATING
C506 EAOUT.n304 VSS 0.02749f ; **FLOATING
C507 EAOUT.n305 VSS 0.02749f ; **FLOATING
C508 EAOUT.n306 VSS 0.02749f ; **FLOATING
C509 EAOUT.n307 VSS 0.02749f ; **FLOATING
C510 EAOUT.n308 VSS 0.02749f ; **FLOATING
C511 EAOUT.n309 VSS 0.02749f ; **FLOATING
C512 EAOUT.n310 VSS 0.02749f ; **FLOATING
C513 EAOUT.n311 VSS 0.02749f ; **FLOATING
C514 EAOUT.n312 VSS 0.02749f ; **FLOATING
C515 EAOUT.n313 VSS 0.02749f ; **FLOATING
C516 EAOUT.n314 VSS 0.01129f ; **FLOATING
C517 EAOUT.n315 VSS 0.01129f ; **FLOATING
C518 EAOUT.n316 VSS 0.01129f ; **FLOATING
C519 EAOUT.n317 VSS 0.01129f ; **FLOATING
C520 EAOUT.n318 VSS 0.01129f ; **FLOATING
C521 EAOUT.n319 VSS 0.01129f ; **FLOATING
C522 EAOUT.n320 VSS 0.01129f ; **FLOATING
C523 EAOUT.n321 VSS 0.01129f ; **FLOATING
C524 EAOUT.n322 VSS 0.01129f ; **FLOATING
C525 EAOUT.n323 VSS 0.01129f ; **FLOATING
C526 EAOUT.n324 VSS 0.01129f ; **FLOATING
C527 EAOUT.n325 VSS 0.01129f ; **FLOATING
C528 EAOUT.n326 VSS 0.01129f ; **FLOATING
C529 EAOUT.n327 VSS 0.01129f ; **FLOATING
C530 EAOUT.n328 VSS 0.01129f ; **FLOATING
C531 EAOUT.n329 VSS 0.01129f ; **FLOATING
C532 EAOUT.n330 VSS 0.01129f ; **FLOATING
C533 EAOUT.n331 VSS 0.01129f ; **FLOATING
C534 EAOUT.n332 VSS 0.01129f ; **FLOATING
C535 EAOUT.n333 VSS 0.01129f ; **FLOATING
C536 EAOUT.n334 VSS 0.01129f ; **FLOATING
C537 EAOUT.n335 VSS 0.01129f ; **FLOATING
C538 EAOUT.n336 VSS 0.01129f ; **FLOATING
C539 EAOUT.n337 VSS 0.01129f ; **FLOATING
C540 EAOUT.n338 VSS 0.01129f ; **FLOATING
C541 EAOUT.n339 VSS 0.01129f ; **FLOATING
C542 EAOUT.n340 VSS 0.01129f ; **FLOATING
C543 EAOUT.n341 VSS 0.01129f ; **FLOATING
C544 EAOUT.n342 VSS 0.01129f ; **FLOATING
C545 EAOUT.n343 VSS 0.01129f ; **FLOATING
C546 EAOUT.n344 VSS 0.01129f ; **FLOATING
C547 EAOUT.n345 VSS 0.01129f ; **FLOATING
C548 EAOUT.n346 VSS 0.01129f ; **FLOATING
C549 EAOUT.n347 VSS 0.01129f ; **FLOATING
C550 EAOUT.n348 VSS 0.01129f ; **FLOATING
C551 EAOUT.n349 VSS 0.01129f ; **FLOATING
C552 EAOUT.n350 VSS 0.01129f ; **FLOATING
C553 EAOUT.n351 VSS 0.01129f ; **FLOATING
C554 EAOUT.n352 VSS 0.01129f ; **FLOATING
C555 EAOUT.n353 VSS 0.01129f ; **FLOATING
C556 EAOUT.n354 VSS 0.01129f ; **FLOATING
C557 EAOUT.n355 VSS 0.01129f ; **FLOATING
C558 EAOUT.n356 VSS 0.01129f ; **FLOATING
C559 EAOUT.n357 VSS 0.01129f ; **FLOATING
C560 EAOUT.n358 VSS 0.01129f ; **FLOATING
C561 EAOUT.n359 VSS 0.01129f ; **FLOATING
C562 EAOUT.t224 VSS 0.08265f ; **FLOATING
C563 EAOUT.n360 VSS 0.05496f ; **FLOATING
C564 EAOUT.t223 VSS 0.07788f ; **FLOATING
C565 EAOUT.n361 VSS 0.04073f ; **FLOATING
C566 EAOUT.t222 VSS 0.07788f ; **FLOATING
C567 EAOUT.n362 VSS 0.05337f ; **FLOATING
C568 EAOUT.t221 VSS 0.07788f ; **FLOATING
C569 EAOUT.n363 VSS 0.05361f ; **FLOATING
C570 EAOUT.t220 VSS 0.07788f ; **FLOATING
C571 EAOUT.n364 VSS 0.04073f ; **FLOATING
C572 EAOUT.t219 VSS 0.07788f ; **FLOATING
C573 EAOUT.n365 VSS 0.05496f ; **FLOATING
C574 EAOUT.t218 VSS 0.07788f ; **FLOATING
C575 EAOUT.n366 VSS 0.05202f ; **FLOATING
C576 EAOUT.t217 VSS 0.07788f ; **FLOATING
C577 EAOUT.n367 VSS 0.05275f ; **FLOATING
C578 EAOUT.t216 VSS 0.07788f ; **FLOATING
C579 EAOUT.n368 VSS 0.05423f ; **FLOATING
C580 EAOUT.t215 VSS 0.07788f ; **FLOATING
C581 EAOUT.n369 VSS 0.04073f ; **FLOATING
C582 EAOUT.t214 VSS 0.07788f ; **FLOATING
C583 EAOUT.n370 VSS 0.05435f ; **FLOATING
C584 EAOUT.t213 VSS 0.07788f ; **FLOATING
C585 EAOUT.n371 VSS 0.05263f ; **FLOATING
C586 EAOUT.t212 VSS 0.07788f ; **FLOATING
C587 EAOUT.n372 VSS 0.05214f ; **FLOATING
C588 EAOUT.t211 VSS 0.07788f ; **FLOATING
C589 EAOUT.n373 VSS 0.05484f ; **FLOATING
C590 EAOUT.t210 VSS 0.07788f ; **FLOATING
C591 EAOUT.n374 VSS 0.04073f ; **FLOATING
C592 EAOUT.t209 VSS 0.07788f ; **FLOATING
C593 EAOUT.n375 VSS 0.05373f ; **FLOATING
C594 EAOUT.t208 VSS 0.07788f ; **FLOATING
C595 EAOUT.n376 VSS 0.05324f ; **FLOATING
C596 EAOUT.t207 VSS 0.07788f ; **FLOATING
C597 EAOUT.n377 VSS 0.04073f ; **FLOATING
C598 EAOUT.t206 VSS 0.07788f ; **FLOATING
C599 EAOUT.n378 VSS 0.05496f ; **FLOATING
C600 EAOUT.t205 VSS 0.07788f ; **FLOATING
C601 EAOUT.n379 VSS 0.04073f ; **FLOATING
C602 EAOUT.t204 VSS 0.07788f ; **FLOATING
C603 EAOUT.n380 VSS 0.05312f ; **FLOATING
C604 EAOUT.t203 VSS 0.07788f ; **FLOATING
C605 EAOUT.n381 VSS 0.05386f ; **FLOATING
C606 EAOUT.t202 VSS 0.07788f ; **FLOATING
C607 EAOUT.n382 VSS 0.04073f ; **FLOATING
C608 EAOUT.t201 VSS 0.07788f ; **FLOATING
C609 EAOUT.n383 VSS 0.05472f ; **FLOATING
C610 EAOUT.t200 VSS 0.07788f ; **FLOATING
C611 EAOUT.n384 VSS 0.05226f ; **FLOATING
C612 EAOUT.t199 VSS 0.07788f ; **FLOATING
C613 EAOUT.n385 VSS 0.05251f ; **FLOATING
C614 EAOUT.t198 VSS 0.07788f ; **FLOATING
C615 EAOUT.n386 VSS 0.05447f ; **FLOATING
C616 EAOUT.t197 VSS 0.07788f ; **FLOATING
C617 EAOUT.n387 VSS 0.04073f ; **FLOATING
C618 EAOUT.t196 VSS 0.07788f ; **FLOATING
C619 EAOUT.n388 VSS 0.0541f ; **FLOATING
C620 EAOUT.t195 VSS 0.07788f ; **FLOATING
C621 EAOUT.n389 VSS 0.05288f ; **FLOATING
C622 EAOUT.t194 VSS 0.07788f ; **FLOATING
C623 EAOUT.n390 VSS 0.04073f ; **FLOATING
C624 EAOUT.t193 VSS 0.07788f ; **FLOATING
C625 EAOUT.n391 VSS 0.05496f ; **FLOATING
C626 EAOUT.t192 VSS 0.07788f ; **FLOATING
C627 EAOUT.n392 VSS 0.04073f ; **FLOATING
C628 EAOUT.t191 VSS 0.07788f ; **FLOATING
C629 EAOUT.n393 VSS 0.05349f ; **FLOATING
C630 EAOUT.t190 VSS 0.07788f ; **FLOATING
C631 EAOUT.n394 VSS 0.05349f ; **FLOATING
C632 EAOUT.t189 VSS 0.07788f ; **FLOATING
C633 EAOUT.n395 VSS 0.04073f ; **FLOATING
C634 EAOUT.t188 VSS 0.07788f ; **FLOATING
C635 EAOUT.n396 VSS 0.05496f ; **FLOATING
C636 EAOUT.t187 VSS 0.07788f ; **FLOATING
C637 EAOUT.n397 VSS 0.04073f ; **FLOATING
C638 EAOUT.t186 VSS 0.07788f ; **FLOATING
C639 EAOUT.n398 VSS 0.05288f ; **FLOATING
C640 EAOUT.t185 VSS 0.07788f ; **FLOATING
C641 EAOUT.n399 VSS 0.0541f ; **FLOATING
C642 EAOUT.t184 VSS 0.07788f ; **FLOATING
C643 EAOUT.n400 VSS 0.04073f ; **FLOATING
C644 EAOUT.t183 VSS 0.07788f ; **FLOATING
C645 EAOUT.n401 VSS 0.05447f ; **FLOATING
C646 EAOUT.t182 VSS 0.07788f ; **FLOATING
C647 EAOUT.n402 VSS 0.05251f ; **FLOATING
C648 EAOUT.t181 VSS 0.07788f ; **FLOATING
C649 EAOUT.n403 VSS 0.05226f ; **FLOATING
C650 EAOUT.t180 VSS 0.07788f ; **FLOATING
C651 EAOUT.n404 VSS 0.05472f ; **FLOATING
C652 EAOUT.t179 VSS 0.07788f ; **FLOATING
C653 EAOUT.n405 VSS 0.04073f ; **FLOATING
C654 EAOUT.t178 VSS 0.07788f ; **FLOATING
C655 EAOUT.n406 VSS 0.05386f ; **FLOATING
C656 EAOUT.t177 VSS 0.07788f ; **FLOATING
C657 EAOUT.n407 VSS 0.05312f ; **FLOATING
C658 EAOUT.t176 VSS 0.07788f ; **FLOATING
C659 EAOUT.n408 VSS 0.04073f ; **FLOATING
C660 EAOUT.t175 VSS 0.07788f ; **FLOATING
C661 EAOUT.n409 VSS 0.05496f ; **FLOATING
C662 EAOUT.t174 VSS 0.07788f ; **FLOATING
C663 EAOUT.n410 VSS 0.04073f ; **FLOATING
C664 EAOUT.t173 VSS 0.07788f ; **FLOATING
C665 EAOUT.n411 VSS 0.05324f ; **FLOATING
C666 EAOUT.t172 VSS 0.07788f ; **FLOATING
C667 EAOUT.n412 VSS 0.05373f ; **FLOATING
C668 EAOUT.t171 VSS 0.07788f ; **FLOATING
C669 EAOUT.n413 VSS 0.04073f ; **FLOATING
C670 EAOUT.t170 VSS 0.07788f ; **FLOATING
C671 EAOUT.n414 VSS 0.05484f ; **FLOATING
C672 EAOUT.t169 VSS 0.07788f ; **FLOATING
C673 EAOUT.n415 VSS 0.05214f ; **FLOATING
C674 EAOUT.t168 VSS 0.07788f ; **FLOATING
C675 EAOUT.n416 VSS 0.05263f ; **FLOATING
C676 EAOUT.t167 VSS 0.07788f ; **FLOATING
C677 EAOUT.n417 VSS 0.05435f ; **FLOATING
C678 EAOUT.t166 VSS 0.07788f ; **FLOATING
C679 EAOUT.n418 VSS 0.04073f ; **FLOATING
C680 EAOUT.t165 VSS 0.07788f ; **FLOATING
C681 EAOUT.n419 VSS 0.05423f ; **FLOATING
C682 EAOUT.t164 VSS 0.07788f ; **FLOATING
C683 EAOUT.n420 VSS 0.05275f ; **FLOATING
C684 EAOUT.t163 VSS 0.07788f ; **FLOATING
C685 EAOUT.n421 VSS 0.05202f ; **FLOATING
C686 EAOUT.t162 VSS 0.07788f ; **FLOATING
C687 EAOUT.n422 VSS 0.05496f ; **FLOATING
C688 EAOUT.t161 VSS 0.07788f ; **FLOATING
C689 EAOUT.n423 VSS 0.04073f ; **FLOATING
C690 EAOUT.t160 VSS 0.07788f ; **FLOATING
C691 EAOUT.n424 VSS 0.05361f ; **FLOATING
C692 EAOUT.t159 VSS 0.07788f ; **FLOATING
C693 EAOUT.n425 VSS 0.05337f ; **FLOATING
C694 EAOUT.t158 VSS 0.07788f ; **FLOATING
C695 EAOUT.n426 VSS 0.04073f ; **FLOATING
C696 EAOUT.t157 VSS 0.07788f ; **FLOATING
C697 EAOUT.n427 VSS 0.05496f ; **FLOATING
C698 EAOUT.t156 VSS 0.07788f ; **FLOATING
C699 EAOUT.t155 VSS 0.07824f ; **FLOATING
C700 EAOUT.n428 VSS 0.04883f ; **FLOATING
C701 EAOUT.n429 VSS 0.07321f ; **FLOATING
C702 EAOUT.n430 VSS 0.05739f ; **FLOATING
C703 EAOUT.n431 VSS 0.02749f ; **FLOATING
C704 EAOUT.n432 VSS 0.02749f ; **FLOATING
C705 EAOUT.n433 VSS 0.02749f ; **FLOATING
C706 EAOUT.n434 VSS 0.02749f ; **FLOATING
C707 EAOUT.n435 VSS 0.02749f ; **FLOATING
C708 EAOUT.n436 VSS 0.02749f ; **FLOATING
C709 EAOUT.n437 VSS 0.02749f ; **FLOATING
C710 EAOUT.n438 VSS 0.02749f ; **FLOATING
C711 EAOUT.n439 VSS 0.02749f ; **FLOATING
C712 EAOUT.n440 VSS 0.02749f ; **FLOATING
C713 EAOUT.n441 VSS 0.02749f ; **FLOATING
C714 EAOUT.n442 VSS 0.02749f ; **FLOATING
C715 EAOUT.n443 VSS 0.02749f ; **FLOATING
C716 EAOUT.n444 VSS 0.02749f ; **FLOATING
C717 EAOUT.n445 VSS 0.02749f ; **FLOATING
C718 EAOUT.n446 VSS 0.02749f ; **FLOATING
C719 EAOUT.n447 VSS 0.02749f ; **FLOATING
C720 EAOUT.n448 VSS 0.02749f ; **FLOATING
C721 EAOUT.n449 VSS 0.02749f ; **FLOATING
C722 EAOUT.n450 VSS 0.02749f ; **FLOATING
C723 EAOUT.n451 VSS 0.02749f ; **FLOATING
C724 EAOUT.n452 VSS 0.02749f ; **FLOATING
C725 EAOUT.n453 VSS 0.02749f ; **FLOATING
C726 EAOUT.n454 VSS 0.02749f ; **FLOATING
C727 EAOUT.n455 VSS 0.02749f ; **FLOATING
C728 EAOUT.n456 VSS 0.02749f ; **FLOATING
C729 EAOUT.n457 VSS 0.02749f ; **FLOATING
C730 EAOUT.n458 VSS 0.02749f ; **FLOATING
C731 EAOUT.n459 VSS 0.02749f ; **FLOATING
C732 EAOUT.n460 VSS 0.02749f ; **FLOATING
C733 EAOUT.n461 VSS 0.02749f ; **FLOATING
C734 EAOUT.n462 VSS 0.02749f ; **FLOATING
C735 EAOUT.n463 VSS 0.02749f ; **FLOATING
C736 EAOUT.n464 VSS 0.02749f ; **FLOATING
C737 EAOUT.n465 VSS 0.02749f ; **FLOATING
C738 EAOUT.n466 VSS 0.02749f ; **FLOATING
C739 EAOUT.n467 VSS 0.02749f ; **FLOATING
C740 EAOUT.n468 VSS 0.02749f ; **FLOATING
C741 EAOUT.n469 VSS 0.02749f ; **FLOATING
C742 EAOUT.n470 VSS 0.02749f ; **FLOATING
C743 EAOUT.n471 VSS 0.02749f ; **FLOATING
C744 EAOUT.n472 VSS 0.02749f ; **FLOATING
C745 EAOUT.n473 VSS 0.02749f ; **FLOATING
C746 EAOUT.n474 VSS 0.02749f ; **FLOATING
C747 EAOUT.n475 VSS 0.02749f ; **FLOATING
C748 EAOUT.n476 VSS 0.02749f ; **FLOATING
C749 EAOUT.n477 VSS 0.02749f ; **FLOATING
C750 EAOUT.n478 VSS 0.02749f ; **FLOATING
C751 EAOUT.n479 VSS 0.02749f ; **FLOATING
C752 EAOUT.n480 VSS 0.02749f ; **FLOATING
C753 EAOUT.n481 VSS 0.02749f ; **FLOATING
C754 EAOUT.n482 VSS 0.02749f ; **FLOATING
C755 EAOUT.n483 VSS 0.02749f ; **FLOATING
C756 EAOUT.n484 VSS 0.02749f ; **FLOATING
C757 EAOUT.n485 VSS 0.02749f ; **FLOATING
C758 EAOUT.n486 VSS 0.02749f ; **FLOATING
C759 EAOUT.n487 VSS 0.02749f ; **FLOATING
C760 EAOUT.n488 VSS 0.02749f ; **FLOATING
C761 EAOUT.n489 VSS 0.02749f ; **FLOATING
C762 EAOUT.n490 VSS 0.02749f ; **FLOATING
C763 EAOUT.n491 VSS 0.02749f ; **FLOATING
C764 EAOUT.n492 VSS 0.02749f ; **FLOATING
C765 EAOUT.n493 VSS 0.02749f ; **FLOATING
C766 EAOUT.n494 VSS 0.02749f ; **FLOATING
C767 EAOUT.n495 VSS 0.02749f ; **FLOATING
C768 EAOUT.n496 VSS 0.02749f ; **FLOATING
C769 EAOUT.n497 VSS 0.02749f ; **FLOATING
C770 EAOUT.n498 VSS 0.02749f ; **FLOATING
C771 EAOUT.n499 VSS 0.02749f ; **FLOATING
C772 EAOUT.n500 VSS 0.02749f ; **FLOATING
C773 EAOUT.n501 VSS 0.02749f ; **FLOATING
C774 EAOUT.n502 VSS 0.02749f ; **FLOATING
C775 EAOUT.n503 VSS 0.02749f ; **FLOATING
C776 EAOUT.n504 VSS 0.02749f ; **FLOATING
C777 EAOUT.n505 VSS 0.02749f ; **FLOATING
C778 EAOUT.n506 VSS 0.02749f ; **FLOATING
C779 EAOUT.n507 VSS 0.02749f ; **FLOATING
C780 EAOUT.n508 VSS 0.02749f ; **FLOATING
C781 EAOUT.n509 VSS 0.02749f ; **FLOATING
C782 EAOUT.n510 VSS 0.02749f ; **FLOATING
C783 EAOUT.n511 VSS 0.02749f ; **FLOATING
C784 EAOUT.n512 VSS 0.02749f ; **FLOATING
C785 EAOUT.n513 VSS 0.02749f ; **FLOATING
C786 EAOUT.n514 VSS 0.02749f ; **FLOATING
C787 EAOUT.n515 VSS 0.02749f ; **FLOATING
C788 EAOUT.n516 VSS 0.02749f ; **FLOATING
C789 EAOUT.n517 VSS 0.02749f ; **FLOATING
C790 EAOUT.n518 VSS 0.02749f ; **FLOATING
C791 EAOUT.n519 VSS 0.02749f ; **FLOATING
C792 EAOUT.n520 VSS 0.02749f ; **FLOATING
C793 EAOUT.n521 VSS 0.02749f ; **FLOATING
C794 EAOUT.n522 VSS 0.02749f ; **FLOATING
C795 EAOUT.n523 VSS 0.08456f ; **FLOATING
C796 EAOUT.n524 VSS 0.04651f ; **FLOATING
C797 EAOUT.t154 VSS 0.08265f ; **FLOATING
C798 EAOUT.n525 VSS 0.01129f ; **FLOATING
C799 EAOUT.n526 VSS 0.01129f ; **FLOATING
C800 EAOUT.n527 VSS 0.01129f ; **FLOATING
C801 EAOUT.n528 VSS 0.01129f ; **FLOATING
C802 EAOUT.n529 VSS 0.01129f ; **FLOATING
C803 EAOUT.n530 VSS 0.01129f ; **FLOATING
C804 EAOUT.n531 VSS 0.01129f ; **FLOATING
C805 EAOUT.n532 VSS 0.01129f ; **FLOATING
C806 EAOUT.n533 VSS 0.01129f ; **FLOATING
C807 EAOUT.n534 VSS 0.01129f ; **FLOATING
C808 EAOUT.n535 VSS 0.01129f ; **FLOATING
C809 EAOUT.n536 VSS 0.01129f ; **FLOATING
C810 EAOUT.n537 VSS 0.01129f ; **FLOATING
C811 EAOUT.n538 VSS 0.01129f ; **FLOATING
C812 EAOUT.n539 VSS 0.01129f ; **FLOATING
C813 EAOUT.n540 VSS 0.01129f ; **FLOATING
C814 EAOUT.n541 VSS 0.01129f ; **FLOATING
C815 EAOUT.n542 VSS 0.01129f ; **FLOATING
C816 EAOUT.n543 VSS 0.01129f ; **FLOATING
C817 EAOUT.n544 VSS 0.01129f ; **FLOATING
C818 EAOUT.n545 VSS 0.01129f ; **FLOATING
C819 EAOUT.n546 VSS 0.01129f ; **FLOATING
C820 EAOUT.n547 VSS 0.01129f ; **FLOATING
C821 EAOUT.n548 VSS 0.01129f ; **FLOATING
C822 EAOUT.n549 VSS 0.01129f ; **FLOATING
C823 EAOUT.n550 VSS 0.01129f ; **FLOATING
C824 EAOUT.n551 VSS 0.01129f ; **FLOATING
C825 EAOUT.n552 VSS 0.01129f ; **FLOATING
C826 EAOUT.n553 VSS 0.01129f ; **FLOATING
C827 EAOUT.n554 VSS 0.01129f ; **FLOATING
C828 EAOUT.n555 VSS 0.01129f ; **FLOATING
C829 EAOUT.n556 VSS 0.01129f ; **FLOATING
C830 EAOUT.n557 VSS 0.01129f ; **FLOATING
C831 EAOUT.n558 VSS 0.01129f ; **FLOATING
C832 EAOUT.n559 VSS 0.01129f ; **FLOATING
C833 EAOUT.n560 VSS 0.01129f ; **FLOATING
C834 EAOUT.n561 VSS 0.01129f ; **FLOATING
C835 EAOUT.n562 VSS 0.01129f ; **FLOATING
C836 EAOUT.n563 VSS 0.01129f ; **FLOATING
C837 EAOUT.n564 VSS 0.01129f ; **FLOATING
C838 EAOUT.n565 VSS 0.01129f ; **FLOATING
C839 EAOUT.n566 VSS 0.01129f ; **FLOATING
C840 EAOUT.n567 VSS 0.05202f ; **FLOATING
C841 EAOUT.n568 VSS 0.01129f ; **FLOATING
C842 EAOUT.n569 VSS 0.01129f ; **FLOATING
C843 EAOUT.n570 VSS 0.01129f ; **FLOATING
C844 EAOUT.n571 VSS 0.01129f ; **FLOATING
C845 EAOUT.n572 VSS 0.04883f ; **FLOATING
C846 EAOUT.t85 VSS 0.07824f ; **FLOATING
C847 EAOUT.n573 VSS 0.05496f ; **FLOATING
C848 EAOUT.t86 VSS 0.07788f ; **FLOATING
C849 EAOUT.n574 VSS 0.04073f ; **FLOATING
C850 EAOUT.t87 VSS 0.07788f ; **FLOATING
C851 EAOUT.n575 VSS 0.05337f ; **FLOATING
C852 EAOUT.t88 VSS 0.07788f ; **FLOATING
C853 EAOUT.n576 VSS 0.05361f ; **FLOATING
C854 EAOUT.t89 VSS 0.07788f ; **FLOATING
C855 EAOUT.n577 VSS 0.04073f ; **FLOATING
C856 EAOUT.t90 VSS 0.07788f ; **FLOATING
C857 EAOUT.n578 VSS 0.05496f ; **FLOATING
C858 EAOUT.t91 VSS 0.07788f ; **FLOATING
C859 EAOUT.t92 VSS 0.07788f ; **FLOATING
C860 EAOUT.n579 VSS 0.05275f ; **FLOATING
C861 EAOUT.t93 VSS 0.07788f ; **FLOATING
C862 EAOUT.n580 VSS 0.05423f ; **FLOATING
C863 EAOUT.t94 VSS 0.07788f ; **FLOATING
C864 EAOUT.n581 VSS 0.04073f ; **FLOATING
C865 EAOUT.t95 VSS 0.07788f ; **FLOATING
C866 EAOUT.n582 VSS 0.05435f ; **FLOATING
C867 EAOUT.t96 VSS 0.07788f ; **FLOATING
C868 EAOUT.n583 VSS 0.05263f ; **FLOATING
C869 EAOUT.t97 VSS 0.07788f ; **FLOATING
C870 EAOUT.n584 VSS 0.05214f ; **FLOATING
C871 EAOUT.t98 VSS 0.07788f ; **FLOATING
C872 EAOUT.n585 VSS 0.05484f ; **FLOATING
C873 EAOUT.t99 VSS 0.07788f ; **FLOATING
C874 EAOUT.n586 VSS 0.04073f ; **FLOATING
C875 EAOUT.t100 VSS 0.07788f ; **FLOATING
C876 EAOUT.n587 VSS 0.05373f ; **FLOATING
C877 EAOUT.t101 VSS 0.07788f ; **FLOATING
C878 EAOUT.n588 VSS 0.05324f ; **FLOATING
C879 EAOUT.t102 VSS 0.07788f ; **FLOATING
C880 EAOUT.n589 VSS 0.04073f ; **FLOATING
C881 EAOUT.t103 VSS 0.07788f ; **FLOATING
C882 EAOUT.n590 VSS 0.05496f ; **FLOATING
C883 EAOUT.t104 VSS 0.07788f ; **FLOATING
C884 EAOUT.n591 VSS 0.04073f ; **FLOATING
C885 EAOUT.t105 VSS 0.07788f ; **FLOATING
C886 EAOUT.n592 VSS 0.05312f ; **FLOATING
C887 EAOUT.t106 VSS 0.07788f ; **FLOATING
C888 EAOUT.n593 VSS 0.05386f ; **FLOATING
C889 EAOUT.t107 VSS 0.07788f ; **FLOATING
C890 EAOUT.n594 VSS 0.04073f ; **FLOATING
C891 EAOUT.t108 VSS 0.07788f ; **FLOATING
C892 EAOUT.n595 VSS 0.05472f ; **FLOATING
C893 EAOUT.t109 VSS 0.07788f ; **FLOATING
C894 EAOUT.n596 VSS 0.05226f ; **FLOATING
C895 EAOUT.t110 VSS 0.07788f ; **FLOATING
C896 EAOUT.n597 VSS 0.05251f ; **FLOATING
C897 EAOUT.t111 VSS 0.07788f ; **FLOATING
C898 EAOUT.n598 VSS 0.05447f ; **FLOATING
C899 EAOUT.t112 VSS 0.07788f ; **FLOATING
C900 EAOUT.n599 VSS 0.04073f ; **FLOATING
C901 EAOUT.t113 VSS 0.07788f ; **FLOATING
C902 EAOUT.n600 VSS 0.0541f ; **FLOATING
C903 EAOUT.t114 VSS 0.07788f ; **FLOATING
C904 EAOUT.n601 VSS 0.05288f ; **FLOATING
C905 EAOUT.t115 VSS 0.07788f ; **FLOATING
C906 EAOUT.n602 VSS 0.04073f ; **FLOATING
C907 EAOUT.t116 VSS 0.07788f ; **FLOATING
C908 EAOUT.n603 VSS 0.05496f ; **FLOATING
C909 EAOUT.t117 VSS 0.07788f ; **FLOATING
C910 EAOUT.n604 VSS 0.04073f ; **FLOATING
C911 EAOUT.t118 VSS 0.07788f ; **FLOATING
C912 EAOUT.n605 VSS 0.05349f ; **FLOATING
C913 EAOUT.t119 VSS 0.07788f ; **FLOATING
C914 EAOUT.n606 VSS 0.05349f ; **FLOATING
C915 EAOUT.t120 VSS 0.07788f ; **FLOATING
C916 EAOUT.n607 VSS 0.04073f ; **FLOATING
C917 EAOUT.t121 VSS 0.07788f ; **FLOATING
C918 EAOUT.n608 VSS 0.05496f ; **FLOATING
C919 EAOUT.t122 VSS 0.07788f ; **FLOATING
C920 EAOUT.n609 VSS 0.04073f ; **FLOATING
C921 EAOUT.t123 VSS 0.07788f ; **FLOATING
C922 EAOUT.n610 VSS 0.05288f ; **FLOATING
C923 EAOUT.t124 VSS 0.07788f ; **FLOATING
C924 EAOUT.n611 VSS 0.0541f ; **FLOATING
C925 EAOUT.t125 VSS 0.07788f ; **FLOATING
C926 EAOUT.n612 VSS 0.04073f ; **FLOATING
C927 EAOUT.t126 VSS 0.07788f ; **FLOATING
C928 EAOUT.n613 VSS 0.05447f ; **FLOATING
C929 EAOUT.t127 VSS 0.07788f ; **FLOATING
C930 EAOUT.n614 VSS 0.05251f ; **FLOATING
C931 EAOUT.t128 VSS 0.07788f ; **FLOATING
C932 EAOUT.n615 VSS 0.05226f ; **FLOATING
C933 EAOUT.t129 VSS 0.07788f ; **FLOATING
C934 EAOUT.n616 VSS 0.05472f ; **FLOATING
C935 EAOUT.t130 VSS 0.07788f ; **FLOATING
C936 EAOUT.n617 VSS 0.04073f ; **FLOATING
C937 EAOUT.t131 VSS 0.07788f ; **FLOATING
C938 EAOUT.n618 VSS 0.05386f ; **FLOATING
C939 EAOUT.t132 VSS 0.07788f ; **FLOATING
C940 EAOUT.n619 VSS 0.05312f ; **FLOATING
C941 EAOUT.t133 VSS 0.07788f ; **FLOATING
C942 EAOUT.n620 VSS 0.04073f ; **FLOATING
C943 EAOUT.t134 VSS 0.07788f ; **FLOATING
C944 EAOUT.n621 VSS 0.05496f ; **FLOATING
C945 EAOUT.t135 VSS 0.07788f ; **FLOATING
C946 EAOUT.n622 VSS 0.04073f ; **FLOATING
C947 EAOUT.t136 VSS 0.07788f ; **FLOATING
C948 EAOUT.n623 VSS 0.05324f ; **FLOATING
C949 EAOUT.t137 VSS 0.07788f ; **FLOATING
C950 EAOUT.n624 VSS 0.05373f ; **FLOATING
C951 EAOUT.t138 VSS 0.07788f ; **FLOATING
C952 EAOUT.n625 VSS 0.04073f ; **FLOATING
C953 EAOUT.t139 VSS 0.07788f ; **FLOATING
C954 EAOUT.n626 VSS 0.05484f ; **FLOATING
C955 EAOUT.t140 VSS 0.07788f ; **FLOATING
C956 EAOUT.n627 VSS 0.05214f ; **FLOATING
C957 EAOUT.t141 VSS 0.07788f ; **FLOATING
C958 EAOUT.n628 VSS 0.05263f ; **FLOATING
C959 EAOUT.t142 VSS 0.07788f ; **FLOATING
C960 EAOUT.n629 VSS 0.05435f ; **FLOATING
C961 EAOUT.t143 VSS 0.07788f ; **FLOATING
C962 EAOUT.n630 VSS 0.04073f ; **FLOATING
C963 EAOUT.t144 VSS 0.07788f ; **FLOATING
C964 EAOUT.n631 VSS 0.05423f ; **FLOATING
C965 EAOUT.t145 VSS 0.07788f ; **FLOATING
C966 EAOUT.n632 VSS 0.05275f ; **FLOATING
C967 EAOUT.t146 VSS 0.07788f ; **FLOATING
C968 EAOUT.n633 VSS 0.05202f ; **FLOATING
C969 EAOUT.t147 VSS 0.07788f ; **FLOATING
C970 EAOUT.n634 VSS 0.05496f ; **FLOATING
C971 EAOUT.t148 VSS 0.07788f ; **FLOATING
C972 EAOUT.n635 VSS 0.04073f ; **FLOATING
C973 EAOUT.t149 VSS 0.07788f ; **FLOATING
C974 EAOUT.n636 VSS 0.05361f ; **FLOATING
C975 EAOUT.t150 VSS 0.07788f ; **FLOATING
C976 EAOUT.n637 VSS 0.05337f ; **FLOATING
C977 EAOUT.t151 VSS 0.07788f ; **FLOATING
C978 EAOUT.n638 VSS 0.04073f ; **FLOATING
C979 EAOUT.t152 VSS 0.07788f ; **FLOATING
C980 EAOUT.n639 VSS 0.05496f ; **FLOATING
C981 EAOUT.t153 VSS 0.07788f ; **FLOATING
C982 EAOUT.n640 VSS 0.28825f ; **FLOATING
C983 EAOUT.n641 VSS 0.01531f ; **FLOATING
C984 EAOUT.n642 VSS 0.0398f ; **FLOATING
C985 EAOUT.t13 VSS 0.14308p ; **FLOATING
C986 EAOUT.n643 VSS 2.61195f ; **FLOATING
C987 EAOUT.t14 VSS 1.0698f ; **FLOATING
C988 EAOUT.n644 VSS 0.41707f ; **FLOATING
C989 EAOUT.n645 VSS 0.38982f ; **FLOATING
C990 v2_pmos_core.EAREF.t12 VSS 0.03335f ; **FLOATING
C991 v2_pmos_core.EAREF.n0 VSS 0.32234f ; **FLOATING
C992 v2_pmos_core.EAREF.t11 VSS 0.35086f ; **FLOATING
C993 v2_pmos_core.EAREF.n1 VSS 1.37898f ; **FLOATING
C994 v2_pmos_core.EAREF.t10 VSS 0.03335f ; **FLOATING
C995 v2_pmos_core.EAREF.t15 VSS 0.03335f ; **FLOATING
C996 v2_pmos_core.EAREF.n2 VSS 0.32234f ; **FLOATING
C997 v2_pmos_core.EAREF.n3 VSS 0.43956f ; **FLOATING
C998 v2_pmos_core.EAREF.t17 VSS 0.03335f ; **FLOATING
C999 v2_pmos_core.EAREF.t8 VSS 0.03335f ; **FLOATING
C1000 v2_pmos_core.EAREF.n4 VSS 0.32234f ; **FLOATING
C1001 v2_pmos_core.EAREF.n5 VSS 0.70398f ; **FLOATING
C1002 v2_pmos_core.EAREF.t9 VSS 0.03335f ; **FLOATING
C1003 v2_pmos_core.EAREF.t19 VSS 0.03335f ; **FLOATING
C1004 v2_pmos_core.EAREF.n6 VSS 0.32234f ; **FLOATING
C1005 v2_pmos_core.EAREF.n7 VSS 0.70398f ; **FLOATING
C1006 v2_pmos_core.EAREF.t13 VSS 0.35749f ; **FLOATING
C1007 v2_pmos_core.EAREF.t14 VSS 0.27785f ; **FLOATING
C1008 v2_pmos_core.EAREF.n8 VSS 1.36385f ; **FLOATING
C1009 v2_pmos_core.EAREF.t16 VSS 0.27785f ; **FLOATING
C1010 v2_pmos_core.EAREF.n9 VSS 0.2887f ; **FLOATING
C1011 v2_pmos_core.EAREF.t25 VSS 0.27785f ; **FLOATING
C1012 v2_pmos_core.EAREF.n10 VSS 0.2887f ; **FLOATING
C1013 v2_pmos_core.EAREF.t24 VSS 0.27785f ; **FLOATING
C1014 v2_pmos_core.EAREF.n11 VSS 0.24005f ; **FLOATING
C1015 v2_pmos_core.EAREF.t23 VSS 0.27785f ; **FLOATING
C1016 v2_pmos_core.EAREF.n12 VSS 0.24005f ; **FLOATING
C1017 v2_pmos_core.EAREF.t22 VSS 0.27785f ; **FLOATING
C1018 v2_pmos_core.EAREF.n13 VSS 0.2887f ; **FLOATING
C1019 v2_pmos_core.EAREF.t18 VSS 0.27785f ; **FLOATING
C1020 v2_pmos_core.EAREF.n14 VSS 0.49932f ; **FLOATING
C1021 v2_pmos_core.EAREF.t20 VSS 0.2788f ; **FLOATING
C1022 v2_pmos_core.EAREF.t1 VSS 1.41923f ; **FLOATING
C1023 v2_pmos_core.EAREF.n15 VSS 1.2865f ; **FLOATING
C1024 v2_pmos_core.EAREF.t0 VSS 0.1334f ; **FLOATING
C1025 v2_pmos_core.EAREF.t6 VSS 0.1334f ; **FLOATING
C1026 v2_pmos_core.EAREF.n16 VSS 1.19121f ; **FLOATING
C1027 v2_pmos_core.EAREF.n17 VSS 0.66704f ; **FLOATING
C1028 v2_pmos_core.EAREF.t7 VSS 0.1334f ; **FLOATING
C1029 v2_pmos_core.EAREF.t3 VSS 0.1334f ; **FLOATING
C1030 v2_pmos_core.EAREF.n18 VSS 1.19121f ; **FLOATING
C1031 v2_pmos_core.EAREF.n19 VSS 1.05574f ; **FLOATING
C1032 v2_pmos_core.EAREF.t2 VSS 1.45907f ; **FLOATING
C1033 v2_pmos_core.EAREF.n20 VSS 0.95893f ; **FLOATING
C1034 v2_pmos_core.EAREF.t4 VSS 0.1334f ; **FLOATING
C1035 v2_pmos_core.EAREF.t5 VSS 0.1334f ; **FLOATING
C1036 v2_pmos_core.EAREF.n21 VSS 1.32468f ; **FLOATING
C1037 v2_pmos_core.EAREF.n22 VSS 1.87346f ; **FLOATING
C1038 v2_pmos_core.EAREF.n23 VSS 0.83825f ; **FLOATING
C1039 v2_pmos_core.EAREF.t21 VSS 0.03335f ; **FLOATING
C1040 v2_pmos_core.EN_5V.t0 VSS 5.29873f ; **FLOATING
C1041 v2_pmos_core.EN_5V.t2 VSS 1.8883f ; **FLOATING
C1042 v2_pmos_core.EN_5V.t1 VSS 4.64785f ; **FLOATING
C1043 v2_pmos_core.EN_5V.n0 VSS 9.54536f ; **FLOATING
C1044 a_22144_8265.t0 VSS 0.02942f ; **FLOATING
C1045 a_22144_8265.n0 VSS 0.31438f ; **FLOATING
C1046 a_22144_8265.t15 VSS 0.02942f ; **FLOATING
C1047 a_22144_8265.t10 VSS 0.02942f ; **FLOATING
C1048 a_22144_8265.n1 VSS 0.40273f ; **FLOATING
C1049 a_22144_8265.t19 VSS 1.49853f ; **FLOATING
C1050 a_22144_8265.n2 VSS 1.21907f ; **FLOATING
C1051 a_22144_8265.t1 VSS 1.49853f ; **FLOATING
C1052 a_22144_8265.n3 VSS 0.43677f ; **FLOATING
C1053 a_22144_8265.t3 VSS 1.49853f ; **FLOATING
C1054 a_22144_8265.n4 VSS 0.73673f ; **FLOATING
C1055 a_22144_8265.t18 VSS 1.51547f ; **FLOATING
C1056 a_22144_8265.n5 VSS 0.99174f ; **FLOATING
C1057 a_22144_8265.t5 VSS 1.49853f ; **FLOATING
C1058 a_22144_8265.n6 VSS 1.24077f ; **FLOATING
C1059 a_22144_8265.t17 VSS 1.49853f ; **FLOATING
C1060 a_22144_8265.n7 VSS 0.43677f ; **FLOATING
C1061 a_22144_8265.t16 VSS 1.49853f ; **FLOATING
C1062 a_22144_8265.n8 VSS 0.73673f ; **FLOATING
C1063 a_22144_8265.t7 VSS 1.51547f ; **FLOATING
C1064 a_22144_8265.t12 VSS 0.59888f ; **FLOATING
C1065 a_22144_8265.n9 VSS 0.91345f ; **FLOATING
C1066 a_22144_8265.t11 VSS 0.05884f ; **FLOATING
C1067 a_22144_8265.t6 VSS 0.05884f ; **FLOATING
C1068 a_22144_8265.n10 VSS 0.53176f ; **FLOATING
C1069 a_22144_8265.n11 VSS 0.57017f ; **FLOATING
C1070 a_22144_8265.t8 VSS 0.05884f ; **FLOATING
C1071 a_22144_8265.t14 VSS 0.05884f ; **FLOATING
C1072 a_22144_8265.n12 VSS 0.53176f ; **FLOATING
C1073 a_22144_8265.n13 VSS 0.89962f ; **FLOATING
C1074 a_22144_8265.t13 VSS 0.62875f ; **FLOATING
C1075 a_22144_8265.n14 VSS 0.84675f ; **FLOATING
C1076 a_22144_8265.t2 VSS 0.05884f ; **FLOATING
C1077 a_22144_8265.t4 VSS 0.05884f ; **FLOATING
C1078 a_22144_8265.n15 VSS 0.63039f ; **FLOATING
C1079 a_22144_8265.n16 VSS 0.82964f ; **FLOATING
C1080 a_22144_8265.n17 VSS 2.25383f ; **FLOATING
C1081 a_22144_8265.t9 VSS 0.02942f ; **FLOATING
C1082 a_22144_9605.t2 VSS 0.0422f ; **FLOATING
C1083 a_22144_9605.n0 VSS 0.49406f ; **FLOATING
C1084 a_22144_9605.t7 VSS 0.0422f ; **FLOATING
C1085 a_22144_9605.t13 VSS 0.0422f ; **FLOATING
C1086 a_22144_9605.n1 VSS 0.49406f ; **FLOATING
C1087 a_22144_9605.n2 VSS 2.78579f ; **FLOATING
C1088 a_22144_9605.t4 VSS 0.0422f ; **FLOATING
C1089 a_22144_9605.t12 VSS 0.0422f ; **FLOATING
C1090 a_22144_9605.n3 VSS 0.51595f ; **FLOATING
C1091 a_22144_9605.t3 VSS 0.08439f ; **FLOATING
C1092 a_22144_9605.t6 VSS 0.08439f ; **FLOATING
C1093 a_22144_9605.n4 VSS 0.89458f ; **FLOATING
C1094 a_22144_9605.n5 VSS 1.07803f ; **FLOATING
C1095 a_22144_9605.t11 VSS 0.98911f ; **FLOATING
C1096 a_22144_9605.n6 VSS 1.39985f ; **FLOATING
C1097 a_22144_9605.t0 VSS 0.08439f ; **FLOATING
C1098 a_22144_9605.t10 VSS 0.08439f ; **FLOATING
C1099 a_22144_9605.n7 VSS 0.82736f ; **FLOATING
C1100 a_22144_9605.n8 VSS 0.88388f ; **FLOATING
C1101 a_22144_9605.t9 VSS 0.08439f ; **FLOATING
C1102 a_22144_9605.t1 VSS 0.08439f ; **FLOATING
C1103 a_22144_9605.n9 VSS 0.82736f ; **FLOATING
C1104 a_22144_9605.n10 VSS 2.0953f ; **FLOATING
C1105 a_22144_9605.t8 VSS 0.96356f ; **FLOATING
C1106 a_22144_9605.n11 VSS 1.30307f ; **FLOATING
C1107 a_22144_9605.t5 VSS 0.0422f ; **FLOATING
C1108 a_23576_3894.t10 VSS 0.03173f ; **FLOATING
C1109 a_23576_3894.n0 VSS 0.35972f ; **FLOATING
C1110 a_23576_3894.t8 VSS 0.03173f ; **FLOATING
C1111 a_23576_3894.t9 VSS 0.03173f ; **FLOATING
C1112 a_23576_3894.n1 VSS 0.34296f ; **FLOATING
C1113 a_23576_3894.n2 VSS 3.30487f ; **FLOATING
C1114 a_23576_3894.t4 VSS 0.12694f ; **FLOATING
C1115 a_23576_3894.t0 VSS 0.12694f ; **FLOATING
C1116 a_23576_3894.n3 VSS 1.18717f ; **FLOATING
C1117 a_23576_3894.n4 VSS 2.96563f ; **FLOATING
C1118 a_23576_3894.t3 VSS 0.12694f ; **FLOATING
C1119 a_23576_3894.t7 VSS 0.12694f ; **FLOATING
C1120 a_23576_3894.n5 VSS 1.22844f ; **FLOATING
C1121 a_23576_3894.n6 VSS 0.73551f ; **FLOATING
C1122 a_23576_3894.t6 VSS 0.12694f ; **FLOATING
C1123 a_23576_3894.t1 VSS 0.12694f ; **FLOATING
C1124 a_23576_3894.n7 VSS 1.22844f ; **FLOATING
C1125 a_23576_3894.t2 VSS 0.12694f ; **FLOATING
C1126 a_23576_3894.t5 VSS 0.12694f ; **FLOATING
C1127 a_23576_3894.n8 VSS 1.18717f ; **FLOATING
C1128 a_23576_3894.t11 VSS 0.03173f ; **FLOATING
C1129 IREF.t7 VSS 0.02459f ; **FLOATING
C1130 IREF.n0 VSS 0.29263f ; **FLOATING
C1131 IREF.t8 VSS 0.23371f ; **FLOATING
C1132 IREF.n1 VSS 1.33408f ; **FLOATING
C1133 IREF.t1 VSS 0.02459f ; **FLOATING
C1134 IREF.t3 VSS 0.02459f ; **FLOATING
C1135 IREF.n2 VSS 0.2427f ; **FLOATING
C1136 IREF.n3 VSS 1.23799f ; **FLOATING
C1137 IREF.t0 VSS 0.25767f ; **FLOATING
C1138 IREF.n4 VSS 1.25299f ; **FLOATING
C1139 IREF.t2 VSS 0.25767f ; **FLOATING
C1140 IREF.n5 VSS 0.21889f ; **FLOATING
C1141 IREF.t13 VSS 0.25767f ; **FLOATING
C1142 IREF.n6 VSS 0.21889f ; **FLOATING
C1143 IREF.t12 VSS 0.25767f ; **FLOATING
C1144 IREF.n7 VSS 0.21889f ; **FLOATING
C1145 IREF.t11 VSS 0.25767f ; **FLOATING
C1146 IREF.n8 VSS 0.21889f ; **FLOATING
C1147 IREF.t10 VSS 0.25767f ; **FLOATING
C1148 IREF.n9 VSS 0.21889f ; **FLOATING
C1149 IREF.t4 VSS 0.25767f ; **FLOATING
C1150 IREF.n10 VSS 0.41435f ; **FLOATING
C1151 IREF.t6 VSS 0.25849f ; **FLOATING
C1152 IREF.n11 VSS 0.97006f ; **FLOATING
C1153 IREF.t9 VSS 0.35483f ; **FLOATING
C1154 IREF.t5 VSS 0.02459f ; **FLOATING
C1155 VIN.t60 VSS 0.51431f ; **FLOATING
C1156 VIN.t19 VSS 0.49904f ; **FLOATING
C1157 VIN.n0 VSS 2.79978f ; **FLOATING
C1158 VIN.n1 VSS 21.9453f ; **FLOATING
C1159 VIN.n2 VSS 9.42806f ; **FLOATING
C1160 VIN.n3 VSS 3.0518f ; **FLOATING
C1161 VIN.n4 VSS 3.0518f ; **FLOATING
C1162 VIN.n5 VSS 3.0518f ; **FLOATING
C1163 VIN.n6 VSS 3.0518f ; **FLOATING
C1164 VIN.n7 VSS 3.0518f ; **FLOATING
C1165 VIN.n8 VSS 3.0518f ; **FLOATING
C1166 VIN.n9 VSS 3.0518f ; **FLOATING
C1167 VIN.n10 VSS 3.0518f ; **FLOATING
C1168 VIN.n11 VSS 3.0518f ; **FLOATING
C1169 VIN.n12 VSS 9.13179f ; **FLOATING
C1170 VIN.n13 VSS 2.00045f ; **FLOATING
C1171 VIN.n14 VSS 0.85878f ; **FLOATING
C1172 VIN.t137 VSS 0.2149f ; **FLOATING
C1173 VIN.n15 VSS 0.13189f ; **FLOATING
C1174 VIN.t259 VSS 0.02154f ; **FLOATING
C1175 VIN.t140 VSS 0.02154f ; **FLOATING
C1176 VIN.n16 VSS 0.18683f ; **FLOATING
C1177 VIN.n17 VSS 0.06472f ; **FLOATING
C1178 VIN.n18 VSS 0.0618f ; **FLOATING
C1179 VIN.n19 VSS 0.0618f ; **FLOATING
C1180 VIN.n20 VSS 0.0618f ; **FLOATING
C1181 VIN.n21 VSS 0.0618f ; **FLOATING
C1182 VIN.n22 VSS 0.0618f ; **FLOATING
C1183 VIN.n23 VSS 0.0618f ; **FLOATING
C1184 VIN.n24 VSS 0.0618f ; **FLOATING
C1185 VIN.n25 VSS 0.1128f ; **FLOATING
C1186 VIN.n26 VSS 0.0618f ; **FLOATING
C1187 VIN.n27 VSS 0.0618f ; **FLOATING
C1188 VIN.n28 VSS 0.0618f ; **FLOATING
C1189 VIN.t130 VSS 0.2149f ; **FLOATING
C1190 VIN.n29 VSS 0.11528f ; **FLOATING
C1191 VIN.t128 VSS 0.02154f ; **FLOATING
C1192 VIN.t126 VSS 0.02154f ; **FLOATING
C1193 VIN.n30 VSS 0.18683f ; **FLOATING
C1194 VIN.n31 VSS 0.06472f ; **FLOATING
C1195 VIN.n32 VSS 0.0618f ; **FLOATING
C1196 VIN.n33 VSS 0.0618f ; **FLOATING
C1197 VIN.n34 VSS 0.0618f ; **FLOATING
C1198 VIN.n35 VSS 0.0618f ; **FLOATING
C1199 VIN.n36 VSS 0.0618f ; **FLOATING
C1200 VIN.n37 VSS 0.0618f ; **FLOATING
C1201 VIN.n38 VSS 0.0618f ; **FLOATING
C1202 VIN.n39 VSS 0.0618f ; **FLOATING
C1203 VIN.n40 VSS 0.0618f ; **FLOATING
C1204 VIN.n41 VSS 0.0618f ; **FLOATING
C1205 VIN.n42 VSS 0.0618f ; **FLOATING
C1206 VIN.t143 VSS 0.2149f ; **FLOATING
C1207 VIN.n43 VSS 0.13189f ; **FLOATING
C1208 VIN.t147 VSS 0.02154f ; **FLOATING
C1209 VIN.t146 VSS 0.02154f ; **FLOATING
C1210 VIN.n44 VSS 0.18683f ; **FLOATING
C1211 VIN.n45 VSS 0.06472f ; **FLOATING
C1212 VIN.n46 VSS 0.0618f ; **FLOATING
C1213 VIN.n47 VSS 0.0618f ; **FLOATING
C1214 VIN.n48 VSS 0.0618f ; **FLOATING
C1215 VIN.n49 VSS 0.0618f ; **FLOATING
C1216 VIN.n50 VSS 0.0618f ; **FLOATING
C1217 VIN.n51 VSS 0.0618f ; **FLOATING
C1218 VIN.n52 VSS 0.0618f ; **FLOATING
C1219 VIN.n53 VSS 0.0618f ; **FLOATING
C1220 VIN.n54 VSS 1.28719f ; **FLOATING
C1221 VIN.n55 VSS 1.51739f ; **FLOATING
C1222 VIN.n56 VSS 0.0618f ; **FLOATING
C1223 VIN.n57 VSS 0.0618f ; **FLOATING
C1224 VIN.n58 VSS 0.01667f ; **FLOATING
C1225 VIN.n59 VSS 0.08686f ; **FLOATING
C1226 VIN.n60 VSS 0.08686f ; **FLOATING
C1227 VIN.n61 VSS 0.02052f ; **FLOATING
C1228 VIN.n62 VSS 0.02052f ; **FLOATING
C1229 VIN.n63 VSS 0.02052f ; **FLOATING
C1230 VIN.n64 VSS 0.02052f ; **FLOATING
C1231 VIN.n65 VSS 0.02052f ; **FLOATING
C1232 VIN.n66 VSS 0.02052f ; **FLOATING
C1233 VIN.n67 VSS 0.08479f ; **FLOATING
C1234 VIN.n68 VSS 1.51739f ; **FLOATING
C1235 VIN.n69 VSS 0.85878f ; **FLOATING
C1236 VIN.n70 VSS 1.20231f ; **FLOATING
C1237 VIN.n71 VSS 0.01026f ; **FLOATING
C1238 VIN.n72 VSS 0.44451f ; **FLOATING
C1239 VIN.n73 VSS 0.08479f ; **FLOATING
C1240 VIN.n74 VSS 1.51739f ; **FLOATING
C1241 VIN.n75 VSS 0.85878f ; **FLOATING
C1242 VIN.n76 VSS 1.20231f ; **FLOATING
C1243 VIN.n77 VSS 0.01026f ; **FLOATING
C1244 VIN.n78 VSS 0.44451f ; **FLOATING
C1245 VIN.n79 VSS 0.08479f ; **FLOATING
C1246 VIN.n80 VSS 1.51739f ; **FLOATING
C1247 VIN.n81 VSS 0.85878f ; **FLOATING
C1248 VIN.n82 VSS 1.20231f ; **FLOATING
C1249 VIN.n83 VSS 0.01026f ; **FLOATING
C1250 VIN.n84 VSS 0.44451f ; **FLOATING
C1251 VIN.n85 VSS 1.51739f ; **FLOATING
C1252 VIN.n86 VSS 0.85878f ; **FLOATING
C1253 VIN.n87 VSS 1.14076f ; **FLOATING
C1254 VIN.n88 VSS 0.02052f ; **FLOATING
C1255 VIN.n89 VSS 0.02044f ; **FLOATING
C1256 VIN.n90 VSS 0.01667f ; **FLOATING
C1257 VIN.n91 VSS 0.13125f ; **FLOATING
C1258 VIN.n92 VSS 0.02052f ; **FLOATING
C1259 VIN.n93 VSS 0.01998f ; **FLOATING
C1260 VIN.n94 VSS 0.02052f ; **FLOATING
C1261 VIN.n95 VSS 0.02052f ; **FLOATING
C1262 VIN.n96 VSS 0.02052f ; **FLOATING
C1263 VIN.n97 VSS 0.02052f ; **FLOATING
C1264 VIN.n98 VSS 0.02052f ; **FLOATING
C1265 VIN.n99 VSS 0.02052f ; **FLOATING
C1266 VIN.n100 VSS 0.02052f ; **FLOATING
C1267 VIN.n101 VSS 0.02052f ; **FLOATING
C1268 VIN.n102 VSS 0.02052f ; **FLOATING
C1269 VIN.n103 VSS 0.02052f ; **FLOATING
C1270 VIN.n104 VSS 0.02052f ; **FLOATING
C1271 VIN.n105 VSS 0.02052f ; **FLOATING
C1272 VIN.n106 VSS 0.02052f ; **FLOATING
C1273 VIN.n107 VSS 0.02052f ; **FLOATING
C1274 VIN.n108 VSS 0.02052f ; **FLOATING
C1275 VIN.n109 VSS 0.02052f ; **FLOATING
C1276 VIN.n110 VSS 0.02052f ; **FLOATING
C1277 VIN.n111 VSS 0.02052f ; **FLOATING
C1278 VIN.n112 VSS 0.02052f ; **FLOATING
C1279 VIN.n113 VSS 0.02052f ; **FLOATING
C1280 VIN.n114 VSS 0.02052f ; **FLOATING
C1281 VIN.n115 VSS 0.02052f ; **FLOATING
C1282 VIN.n116 VSS 0.02052f ; **FLOATING
C1283 VIN.n117 VSS 0.02052f ; **FLOATING
C1284 VIN.n118 VSS 0.02052f ; **FLOATING
C1285 VIN.n119 VSS 0.02052f ; **FLOATING
C1286 VIN.n120 VSS 0.02052f ; **FLOATING
C1287 VIN.n121 VSS 0.02052f ; **FLOATING
C1288 VIN.n122 VSS 0.02052f ; **FLOATING
C1289 VIN.n123 VSS 0.02052f ; **FLOATING
C1290 VIN.n124 VSS 0.02052f ; **FLOATING
C1291 VIN.n125 VSS 0.02052f ; **FLOATING
C1292 VIN.n126 VSS 0.02052f ; **FLOATING
C1293 VIN.n127 VSS 0.02052f ; **FLOATING
C1294 VIN.n128 VSS 2.47285f ; **FLOATING
C1295 VIN.n129 VSS 0.3992f ; **FLOATING
C1296 VIN.n130 VSS 0.18177f ; **FLOATING
C1297 VIN.n131 VSS 0.01667f ; **FLOATING
C1298 VIN.n132 VSS 0.06282f ; **FLOATING
C1299 VIN.n133 VSS 0.06282f ; **FLOATING
C1300 VIN.n134 VSS 0.02052f ; **FLOATING
C1301 VIN.n135 VSS 0.02052f ; **FLOATING
C1302 VIN.n136 VSS 0.02052f ; **FLOATING
C1303 VIN.n137 VSS 0.02052f ; **FLOATING
C1304 VIN.n138 VSS 0.02052f ; **FLOATING
C1305 VIN.n139 VSS 0.02052f ; **FLOATING
C1306 VIN.n140 VSS 0.02052f ; **FLOATING
C1307 VIN.n141 VSS 0.02052f ; **FLOATING
C1308 VIN.n142 VSS 0.02052f ; **FLOATING
C1309 VIN.n143 VSS 0.02052f ; **FLOATING
C1310 VIN.n144 VSS 0.02052f ; **FLOATING
C1311 VIN.n145 VSS 0.02052f ; **FLOATING
C1312 VIN.n146 VSS 0.02052f ; **FLOATING
C1313 VIN.n147 VSS 0.02052f ; **FLOATING
C1314 VIN.n148 VSS 0.02052f ; **FLOATING
C1315 VIN.n149 VSS 0.02052f ; **FLOATING
C1316 VIN.n150 VSS 0.02052f ; **FLOATING
C1317 VIN.n151 VSS 0.02052f ; **FLOATING
C1318 VIN.n152 VSS 0.02052f ; **FLOATING
C1319 VIN.n153 VSS 0.02052f ; **FLOATING
C1320 VIN.n154 VSS 0.02052f ; **FLOATING
C1321 VIN.n155 VSS 0.02052f ; **FLOATING
C1322 VIN.n156 VSS 0.02052f ; **FLOATING
C1323 VIN.n157 VSS 0.02052f ; **FLOATING
C1324 VIN.n158 VSS 0.02052f ; **FLOATING
C1325 VIN.n159 VSS 0.02052f ; **FLOATING
C1326 VIN.n160 VSS 0.02052f ; **FLOATING
C1327 VIN.n161 VSS 0.02052f ; **FLOATING
C1328 VIN.n162 VSS 0.02052f ; **FLOATING
C1329 VIN.n163 VSS 0.02052f ; **FLOATING
C1330 VIN.n164 VSS 0.02052f ; **FLOATING
C1331 VIN.n165 VSS 0.02052f ; **FLOATING
C1332 VIN.n166 VSS 0.02052f ; **FLOATING
C1333 VIN.n167 VSS 0.02052f ; **FLOATING
C1334 VIN.n168 VSS 0.02052f ; **FLOATING
C1335 VIN.n169 VSS 0.02052f ; **FLOATING
C1336 VIN.n170 VSS 0.02052f ; **FLOATING
C1337 VIN.n171 VSS 0.02052f ; **FLOATING
C1338 VIN.n172 VSS 0.0141f ; **FLOATING
C1339 VIN.n173 VSS 0.02052f ; **FLOATING
C1340 VIN.n174 VSS 0.01667f ; **FLOATING
C1341 VIN.n175 VSS 0.02052f ; **FLOATING
C1342 VIN.n176 VSS 0.02052f ; **FLOATING
C1343 VIN.n177 VSS 0.02052f ; **FLOATING
C1344 VIN.n178 VSS 0.02052f ; **FLOATING
C1345 VIN.n179 VSS 0.02052f ; **FLOATING
C1346 VIN.n180 VSS 0.02052f ; **FLOATING
C1347 VIN.n181 VSS 0.02052f ; **FLOATING
C1348 VIN.n182 VSS 0.02052f ; **FLOATING
C1349 VIN.n183 VSS 0.02052f ; **FLOATING
C1350 VIN.n184 VSS 0.02052f ; **FLOATING
C1351 VIN.n185 VSS 0.02052f ; **FLOATING
C1352 VIN.n186 VSS 0.02052f ; **FLOATING
C1353 VIN.n187 VSS 0.02052f ; **FLOATING
C1354 VIN.n188 VSS 0.02052f ; **FLOATING
C1355 VIN.n189 VSS 0.02052f ; **FLOATING
C1356 VIN.n190 VSS 0.02052f ; **FLOATING
C1357 VIN.n191 VSS 0.02052f ; **FLOATING
C1358 VIN.n192 VSS 0.02052f ; **FLOATING
C1359 VIN.n193 VSS 0.02052f ; **FLOATING
C1360 VIN.n194 VSS 0.02052f ; **FLOATING
C1361 VIN.n195 VSS 0.02052f ; **FLOATING
C1362 VIN.n196 VSS 0.02052f ; **FLOATING
C1363 VIN.n197 VSS 0.02052f ; **FLOATING
C1364 VIN.n198 VSS 0.02052f ; **FLOATING
C1365 VIN.n199 VSS 0.02052f ; **FLOATING
C1366 VIN.n200 VSS 0.02052f ; **FLOATING
C1367 VIN.n201 VSS 0.02052f ; **FLOATING
C1368 VIN.n202 VSS 0.02052f ; **FLOATING
C1369 VIN.n203 VSS 0.02052f ; **FLOATING
C1370 VIN.n204 VSS 0.02052f ; **FLOATING
C1371 VIN.n205 VSS 0.02052f ; **FLOATING
C1372 VIN.n206 VSS 0.02052f ; **FLOATING
C1373 VIN.n207 VSS 0.02052f ; **FLOATING
C1374 VIN.n208 VSS 0.02052f ; **FLOATING
C1375 VIN.n209 VSS 0.02052f ; **FLOATING
C1376 VIN.n210 VSS 0.02052f ; **FLOATING
C1377 VIN.n211 VSS 0.02052f ; **FLOATING
C1378 VIN.n212 VSS 0.02052f ; **FLOATING
C1379 VIN.n213 VSS 0.02052f ; **FLOATING
C1380 VIN.n214 VSS 0.02052f ; **FLOATING
C1381 VIN.n215 VSS 0.02052f ; **FLOATING
C1382 VIN.n216 VSS 0.01667f ; **FLOATING
C1383 VIN.n217 VSS 0.02052f ; **FLOATING
C1384 VIN.n218 VSS 0.0141f ; **FLOATING
C1385 VIN.n219 VSS 0.02052f ; **FLOATING
C1386 VIN.n220 VSS 0.02052f ; **FLOATING
C1387 VIN.n221 VSS 0.02052f ; **FLOATING
C1388 VIN.n222 VSS 0.02052f ; **FLOATING
C1389 VIN.n223 VSS 0.02052f ; **FLOATING
C1390 VIN.n224 VSS 0.02052f ; **FLOATING
C1391 VIN.n225 VSS 0.02052f ; **FLOATING
C1392 VIN.n226 VSS 0.02052f ; **FLOATING
C1393 VIN.n227 VSS 0.02052f ; **FLOATING
C1394 VIN.n228 VSS 0.02052f ; **FLOATING
C1395 VIN.n229 VSS 0.02052f ; **FLOATING
C1396 VIN.n230 VSS 0.02052f ; **FLOATING
C1397 VIN.n231 VSS 0.02052f ; **FLOATING
C1398 VIN.n232 VSS 0.02052f ; **FLOATING
C1399 VIN.n233 VSS 0.02052f ; **FLOATING
C1400 VIN.n234 VSS 0.02052f ; **FLOATING
C1401 VIN.n235 VSS 0.02052f ; **FLOATING
C1402 VIN.n236 VSS 0.02052f ; **FLOATING
C1403 VIN.n237 VSS 0.02052f ; **FLOATING
C1404 VIN.n238 VSS 0.02052f ; **FLOATING
C1405 VIN.n239 VSS 0.02052f ; **FLOATING
C1406 VIN.n240 VSS 0.02052f ; **FLOATING
C1407 VIN.n241 VSS 0.02052f ; **FLOATING
C1408 VIN.n242 VSS 0.02052f ; **FLOATING
C1409 VIN.n243 VSS 0.02052f ; **FLOATING
C1410 VIN.n244 VSS 0.02052f ; **FLOATING
C1411 VIN.n245 VSS 0.02052f ; **FLOATING
C1412 VIN.n246 VSS 0.02052f ; **FLOATING
C1413 VIN.n247 VSS 0.02052f ; **FLOATING
C1414 VIN.n248 VSS 0.02052f ; **FLOATING
C1415 VIN.n249 VSS 0.02052f ; **FLOATING
C1416 VIN.n250 VSS 0.02052f ; **FLOATING
C1417 VIN.n251 VSS 0.02052f ; **FLOATING
C1418 VIN.n252 VSS 0.02052f ; **FLOATING
C1419 VIN.n253 VSS 0.02052f ; **FLOATING
C1420 VIN.n254 VSS 0.02052f ; **FLOATING
C1421 VIN.n255 VSS 0.02052f ; **FLOATING
C1422 VIN.n256 VSS 0.02052f ; **FLOATING
C1423 VIN.n257 VSS 0.02052f ; **FLOATING
C1424 VIN.n258 VSS 0.18177f ; **FLOATING
C1425 VIN.t38 VSS 0.01795f ; **FLOATING
C1426 VIN.t67 VSS 0.01795f ; **FLOATING
C1427 VIN.n259 VSS 0.17638f ; **FLOATING
C1428 VIN.n260 VSS 0.65077f ; **FLOATING
C1429 VIN.t35 VSS 0.01795f ; **FLOATING
C1430 VIN.t66 VSS 0.01795f ; **FLOATING
C1431 VIN.n261 VSS 0.18414f ; **FLOATING
C1432 VIN.n262 VSS 0.65077f ; **FLOATING
C1433 VIN.t80 VSS 0.01795f ; **FLOATING
C1434 VIN.t23 VSS 0.01795f ; **FLOATING
C1435 VIN.n263 VSS 0.18414f ; **FLOATING
C1436 VIN.t124 VSS 0.01795f ; **FLOATING
C1437 VIN.t256 VSS 0.01795f ; **FLOATING
C1438 VIN.n264 VSS 0.17638f ; **FLOATING
C1439 VIN.n265 VSS 2.47285f ; **FLOATING
C1440 VIN.n266 VSS 0.3992f ; **FLOATING
C1441 VIN.n267 VSS 0.01667f ; **FLOATING
C1442 VIN.n268 VSS 0.13125f ; **FLOATING
C1443 VIN.n269 VSS 0.02052f ; **FLOATING
C1444 VIN.n270 VSS 0.02052f ; **FLOATING
C1445 VIN.n271 VSS 0.02052f ; **FLOATING
C1446 VIN.n272 VSS 0.02052f ; **FLOATING
C1447 VIN.n273 VSS 0.02052f ; **FLOATING
C1448 VIN.n274 VSS 0.02052f ; **FLOATING
C1449 VIN.n275 VSS 0.02052f ; **FLOATING
C1450 VIN.n276 VSS 0.02052f ; **FLOATING
C1451 VIN.n277 VSS 0.02052f ; **FLOATING
C1452 VIN.n278 VSS 0.02052f ; **FLOATING
C1453 VIN.n279 VSS 0.02052f ; **FLOATING
C1454 VIN.n280 VSS 0.02052f ; **FLOATING
C1455 VIN.n281 VSS 0.02052f ; **FLOATING
C1456 VIN.n282 VSS 0.02052f ; **FLOATING
C1457 VIN.n283 VSS 0.02052f ; **FLOATING
C1458 VIN.n284 VSS 0.02052f ; **FLOATING
C1459 VIN.n285 VSS 0.02052f ; **FLOATING
C1460 VIN.n286 VSS 0.02052f ; **FLOATING
C1461 VIN.n287 VSS 0.02052f ; **FLOATING
C1462 VIN.n288 VSS 0.02052f ; **FLOATING
C1463 VIN.n289 VSS 0.02052f ; **FLOATING
C1464 VIN.n290 VSS 0.01997f ; **FLOATING
C1465 VIN.n291 VSS 0.02052f ; **FLOATING
C1466 VIN.n292 VSS 0.02044f ; **FLOATING
C1467 VIN.n293 VSS 0.03815f ; **FLOATING
C1468 VIN.n294 VSS 1.51739f ; **FLOATING
C1469 VIN.n295 VSS 0.85878f ; **FLOATING
C1470 VIN.n296 VSS 1.14076f ; **FLOATING
C1471 VIN.n297 VSS 0.02052f ; **FLOATING
C1472 VIN.n298 VSS 0.01998f ; **FLOATING
C1473 VIN.n299 VSS 0.02052f ; **FLOATING
C1474 VIN.n300 VSS 0.02052f ; **FLOATING
C1475 VIN.n301 VSS 0.02052f ; **FLOATING
C1476 VIN.n302 VSS 0.02052f ; **FLOATING
C1477 VIN.n303 VSS 0.02052f ; **FLOATING
C1478 VIN.n304 VSS 0.02052f ; **FLOATING
C1479 VIN.n305 VSS 0.02052f ; **FLOATING
C1480 VIN.n306 VSS 0.02052f ; **FLOATING
C1481 VIN.n307 VSS 0.02052f ; **FLOATING
C1482 VIN.n308 VSS 0.02052f ; **FLOATING
C1483 VIN.n309 VSS 0.02052f ; **FLOATING
C1484 VIN.n310 VSS 0.02052f ; **FLOATING
C1485 VIN.n311 VSS 0.02052f ; **FLOATING
C1486 VIN.n312 VSS 0.02052f ; **FLOATING
C1487 VIN.n313 VSS 0.02052f ; **FLOATING
C1488 VIN.n314 VSS 0.02052f ; **FLOATING
C1489 VIN.n315 VSS 0.02052f ; **FLOATING
C1490 VIN.n316 VSS 0.02052f ; **FLOATING
C1491 VIN.n317 VSS 0.02052f ; **FLOATING
C1492 VIN.n318 VSS 0.02052f ; **FLOATING
C1493 VIN.n319 VSS 0.02052f ; **FLOATING
C1494 VIN.n320 VSS 0.02052f ; **FLOATING
C1495 VIN.n321 VSS 0.02052f ; **FLOATING
C1496 VIN.n322 VSS 0.02052f ; **FLOATING
C1497 VIN.n323 VSS 0.02052f ; **FLOATING
C1498 VIN.n324 VSS 0.02052f ; **FLOATING
C1499 VIN.n325 VSS 0.02052f ; **FLOATING
C1500 VIN.n326 VSS 0.01997f ; **FLOATING
C1501 VIN.n327 VSS 0.03815f ; **FLOATING
C1502 VIN.n328 VSS 1.51739f ; **FLOATING
C1503 VIN.n329 VSS 0.85878f ; **FLOATING
C1504 VIN.n330 VSS 1.14076f ; **FLOATING
C1505 VIN.n331 VSS 0.02052f ; **FLOATING
C1506 VIN.n332 VSS 0.02044f ; **FLOATING
C1507 VIN.n333 VSS 0.02052f ; **FLOATING
C1508 VIN.n334 VSS 0.01998f ; **FLOATING
C1509 VIN.n335 VSS 0.02052f ; **FLOATING
C1510 VIN.n336 VSS 0.02052f ; **FLOATING
C1511 VIN.n337 VSS 0.02052f ; **FLOATING
C1512 VIN.n338 VSS 0.02052f ; **FLOATING
C1513 VIN.n339 VSS 0.02052f ; **FLOATING
C1514 VIN.n340 VSS 0.02052f ; **FLOATING
C1515 VIN.n341 VSS 0.02052f ; **FLOATING
C1516 VIN.n342 VSS 0.02052f ; **FLOATING
C1517 VIN.n343 VSS 0.02052f ; **FLOATING
C1518 VIN.n344 VSS 0.02052f ; **FLOATING
C1519 VIN.n345 VSS 0.02052f ; **FLOATING
C1520 VIN.n346 VSS 0.02052f ; **FLOATING
C1521 VIN.n347 VSS 0.02052f ; **FLOATING
C1522 VIN.n348 VSS 0.02052f ; **FLOATING
C1523 VIN.n349 VSS 0.02052f ; **FLOATING
C1524 VIN.n350 VSS 0.02052f ; **FLOATING
C1525 VIN.n351 VSS 0.02052f ; **FLOATING
C1526 VIN.n352 VSS 0.02052f ; **FLOATING
C1527 VIN.n353 VSS 0.02052f ; **FLOATING
C1528 VIN.n354 VSS 0.02052f ; **FLOATING
C1529 VIN.n355 VSS 0.02052f ; **FLOATING
C1530 VIN.n356 VSS 0.02052f ; **FLOATING
C1531 VIN.n357 VSS 0.02052f ; **FLOATING
C1532 VIN.n358 VSS 0.02052f ; **FLOATING
C1533 VIN.n359 VSS 0.02052f ; **FLOATING
C1534 VIN.n360 VSS 0.02052f ; **FLOATING
C1535 VIN.n361 VSS 0.02052f ; **FLOATING
C1536 VIN.n362 VSS 2.00108f ; **FLOATING
C1537 VIN.n363 VSS 0.06207f ; **FLOATING
C1538 VIN.n364 VSS 1.42543f ; **FLOATING
C1539 VIN.n365 VSS 0.01477f ; **FLOATING
C1540 VIN.n366 VSS 1.42543f ; **FLOATING
C1541 VIN.n367 VSS 0.01477f ; **FLOATING
C1542 VIN.n368 VSS 1.42543f ; **FLOATING
C1543 VIN.n369 VSS 0.01477f ; **FLOATING
C1544 VIN.n370 VSS 1.42543f ; **FLOATING
C1545 VIN.n371 VSS 0.01477f ; **FLOATING
C1546 VIN.n372 VSS 1.42543f ; **FLOATING
C1547 VIN.n373 VSS 0.01477f ; **FLOATING
C1548 VIN.n374 VSS 1.33634f ; **FLOATING
C1549 VIN.n375 VSS 0.01477f ; **FLOATING
C1550 VIN.n376 VSS 0.8018f ; **FLOATING
C1551 VIN.n377 VSS 0.01477f ; **FLOATING
C1552 VIN.n378 VSS 1.42543f ; **FLOATING
C1553 VIN.n379 VSS 0.01477f ; **FLOATING
C1554 VIN.n380 VSS 1.42543f ; **FLOATING
C1555 VIN.n381 VSS 0.01477f ; **FLOATING
C1556 VIN.n382 VSS 1.02452f ; **FLOATING
C1557 VIN.n383 VSS 0.01477f ; **FLOATING
C1558 VIN.n384 VSS 1.11361f ; **FLOATING
C1559 VIN.n385 VSS 0.01477f ; **FLOATING
C1560 VIN.n386 VSS 1.42543f ; **FLOATING
C1561 VIN.n387 VSS 0.01477f ; **FLOATING
C1562 VIN.n388 VSS 1.42543f ; **FLOATING
C1563 VIN.n389 VSS 0.01477f ; **FLOATING
C1564 VIN.t262 VSS 0.76617f ; **FLOATING
C1565 VIN.n390 VSS 0.01477f ; **FLOATING
C1566 VIN.n391 VSS 0.97998f ; **FLOATING
C1567 VIN.n392 VSS 0.01477f ; **FLOATING
C1568 VIN.n393 VSS 1.1047f ; **FLOATING
C1569 VIN.n394 VSS 0.01477f ; **FLOATING
C1570 VIN.n395 VSS 1.42543f ; **FLOATING
C1571 VIN.n396 VSS 0.01477f ; **FLOATING
C1572 VIN.n397 VSS 1.42543f ; **FLOATING
C1573 VIN.n398 VSS 0.01477f ; **FLOATING
C1574 VIN.n399 VSS 1.42543f ; **FLOATING
C1575 VIN.n400 VSS 0.01477f ; **FLOATING
C1576 VIN.n401 VSS 0.97998f ; **FLOATING
C1577 VIN.n402 VSS 0.01477f ; **FLOATING
C1578 VIN.n403 VSS 0.97553f ; **FLOATING
C1579 VIN.n404 VSS 0.01477f ; **FLOATING
C1580 VIN.n405 VSS 1.42543f ; **FLOATING
C1581 VIN.n406 VSS 0.01477f ; **FLOATING
C1582 VIN.n407 VSS 1.33188f ; **FLOATING
C1583 VIN.n408 VSS 0.01477f ; **FLOATING
C1584 VIN.n409 VSS 0.68153f ; **FLOATING
C1585 VIN.n410 VSS 0.01477f ; **FLOATING
C1586 VIN.n411 VSS 0.30736f ; **FLOATING
C1587 VIN.n412 VSS 0.01477f ; **FLOATING
C1588 VIN.n413 VSS 0.98889f ; **FLOATING
C1589 VIN.n414 VSS 0.01477f ; **FLOATING
C1590 VIN.n415 VSS 0.96662f ; **FLOATING
C1591 VIN.n416 VSS 0.01477f ; **FLOATING
C1592 VIN.n417 VSS 0.73498f ; **FLOATING
C1593 VIN.n418 VSS 0.01477f ; **FLOATING
C1594 VIN.n419 VSS 0.88644f ; **FLOATING
C1595 VIN.n420 VSS 0.01477f ; **FLOATING
C1596 VIN.n421 VSS 0.98889f ; **FLOATING
C1597 VIN.n422 VSS 0.01477f ; **FLOATING
C1598 VIN.n423 VSS 0.49444f ; **FLOATING
C1599 VIN.n424 VSS 0.01477f ; **FLOATING
C1600 VIN.n425 VSS 0.49444f ; **FLOATING
C1601 VIN.n426 VSS 0.01477f ; **FLOATING
C1602 VIN.n427 VSS 0.98889f ; **FLOATING
C1603 VIN.n428 VSS 0.01477f ; **FLOATING
C1604 VIN.n429 VSS 0.88644f ; **FLOATING
C1605 VIN.n430 VSS 0.01477f ; **FLOATING
C1606 VIN.n431 VSS 0.73498f ; **FLOATING
C1607 VIN.n432 VSS 0.01477f ; **FLOATING
C1608 VIN.n433 VSS 0.96662f ; **FLOATING
C1609 VIN.n434 VSS 0.01477f ; **FLOATING
C1610 VIN.n435 VSS 0.98889f ; **FLOATING
C1611 VIN.n436 VSS 0.01477f ; **FLOATING
C1612 VIN.n437 VSS 0.30736f ; **FLOATING
C1613 VIN.n438 VSS 0.01477f ; **FLOATING
C1614 VIN.n439 VSS 0.68153f ; **FLOATING
C1615 VIN.n440 VSS 0.01477f ; **FLOATING
C1616 VIN.n441 VSS 1.33188f ; **FLOATING
C1617 VIN.n442 VSS 0.01477f ; **FLOATING
C1618 VIN.n443 VSS 1.42543f ; **FLOATING
C1619 VIN.n444 VSS 0.01477f ; **FLOATING
C1620 VIN.n445 VSS 0.97553f ; **FLOATING
C1621 VIN.n446 VSS 0.01477f ; **FLOATING
C1622 VIN.n447 VSS 0.97998f ; **FLOATING
C1623 VIN.n448 VSS 0.01477f ; **FLOATING
C1624 VIN.n449 VSS 1.42543f ; **FLOATING
C1625 VIN.n450 VSS 0.01477f ; **FLOATING
C1626 VIN.n451 VSS 1.42543f ; **FLOATING
C1627 VIN.n452 VSS 0.01477f ; **FLOATING
C1628 VIN.n453 VSS 1.42543f ; **FLOATING
C1629 VIN.n454 VSS 0.01477f ; **FLOATING
C1630 VIN.n455 VSS 1.42543f ; **FLOATING
C1631 VIN.n456 VSS 0.01477f ; **FLOATING
C1632 VIN.n457 VSS 1.37197f ; **FLOATING
C1633 VIN.n458 VSS 0.01477f ; **FLOATING
C1634 VIN.n459 VSS 0.76617f ; **FLOATING
C1635 VIN.n460 VSS 0.01477f ; **FLOATING
C1636 VIN.n461 VSS 1.42543f ; **FLOATING
C1637 VIN.n462 VSS 0.01477f ; **FLOATING
C1638 VIN.n463 VSS 1.42543f ; **FLOATING
C1639 VIN.n464 VSS 0.01477f ; **FLOATING
C1640 VIN.n465 VSS 1.42543f ; **FLOATING
C1641 VIN.n466 VSS 0.01477f ; **FLOATING
C1642 VIN.n467 VSS 1.42543f ; **FLOATING
C1643 VIN.n468 VSS 0.01477f ; **FLOATING
C1644 VIN.n469 VSS 1.42543f ; **FLOATING
C1645 VIN.n470 VSS 0.01477f ; **FLOATING
C1646 VIN.n471 VSS 1.42543f ; **FLOATING
C1647 VIN.n472 VSS 0.01477f ; **FLOATING
C1648 VIN.n473 VSS 1.42543f ; **FLOATING
C1649 VIN.n474 VSS 0.01477f ; **FLOATING
C1650 VIN.n475 VSS 1.42543f ; **FLOATING
C1651 VIN.n476 VSS 0.01477f ; **FLOATING
C1652 VIN.n477 VSS 1.42543f ; **FLOATING
C1653 VIN.n478 VSS 0.01477f ; **FLOATING
C1654 VIN.n479 VSS 1.42543f ; **FLOATING
C1655 VIN.n480 VSS 0.01477f ; **FLOATING
C1656 VIN.n481 VSS 1.42543f ; **FLOATING
C1657 VIN.n482 VSS 0.01477f ; **FLOATING
C1658 VIN.n483 VSS 1.42543f ; **FLOATING
C1659 VIN.n484 VSS 0.01477f ; **FLOATING
C1660 VIN.n485 VSS 1.42543f ; **FLOATING
C1661 VIN.n486 VSS 0.01477f ; **FLOATING
C1662 VIN.n487 VSS 0.47928f ; **FLOATING
C1663 VIN.n488 VSS 0.62852f ; **FLOATING
C1664 VIN.t117 VSS 0.10341f ; **FLOATING
C1665 VIN.t223 VSS 0.11134f ; **FLOATING
C1666 VIN.t225 VSS 0.10741f ; **FLOATING
C1667 VIN.n489 VSS 0.63792f ; **FLOATING
C1668 VIN.t227 VSS 0.10741f ; **FLOATING
C1669 VIN.n490 VSS 0.16359f ; **FLOATING
C1670 VIN.t229 VSS 0.10741f ; **FLOATING
C1671 VIN.n491 VSS 0.50307f ; **FLOATING
C1672 VIN.n492 VSS 0.06547f ; **FLOATING
C1673 VIN.n493 VSS 0.47876f ; **FLOATING
C1674 VIN.n494 VSS 0.62852f ; **FLOATING
C1675 VIN.t329 VSS 0.3541f ; **FLOATING
C1676 VIN.t265 VSS 0.3031f ; **FLOATING
C1677 VIN.n495 VSS 0.51729f ; **FLOATING
C1678 VIN.t263 VSS 0.3031f ; **FLOATING
C1679 VIN.n496 VSS 0.28821f ; **FLOATING
C1680 VIN.t261 VSS 0.30307f ; **FLOATING
C1681 VIN.n497 VSS 0.29427f ; **FLOATING
C1682 VIN.n498 VSS 0.20516f ; **FLOATING
C1683 VIN.t231 VSS 0.04695f ; **FLOATING
C1684 VIN.t234 VSS 0.03223f ; **FLOATING
C1685 VIN.t233 VSS 0.03223f ; **FLOATING
C1686 VIN.n499 VSS 0.18019f ; **FLOATING
C1687 VIN.n500 VSS 0.20516f ; **FLOATING
C1688 VIN.t219 VSS 0.04695f ; **FLOATING
C1689 VIN.t222 VSS 0.03223f ; **FLOATING
C1690 VIN.t221 VSS 0.03223f ; **FLOATING
C1691 VIN.n501 VSS 0.57014f ; **FLOATING
C1692 VIN.t239 VSS 0.53881f ; **FLOATING
C1693 VIN.t241 VSS 0.53772f ; **FLOATING
C1694 VIN.n502 VSS 0.14921f ; **FLOATING
C1695 VIN.n503 VSS 0.20514f ; **FLOATING
C1696 VIN.n504 VSS 0.14503f ; **FLOATING
C1697 VIN.n505 VSS 0.01477f ; **FLOATING
C1698 VIN.n506 VSS 0.01477f ; **FLOATING
C1699 VIN.n507 VSS 0.01477f ; **FLOATING
C1700 VIN.n508 VSS 0.01477f ; **FLOATING
C1701 VIN.n509 VSS 0.01477f ; **FLOATING
C1702 VIN.n510 VSS 0.01477f ; **FLOATING
C1703 VIN.n511 VSS 0.01477f ; **FLOATING
C1704 VIN.n512 VSS 0.01477f ; **FLOATING
C1705 VIN.n513 VSS 0.01477f ; **FLOATING
C1706 VIN.n514 VSS 0.01477f ; **FLOATING
C1707 VIN.n515 VSS 0.01477f ; **FLOATING
C1708 VIN.n516 VSS 0.01477f ; **FLOATING
C1709 VIN.n517 VSS 0.01477f ; **FLOATING
C1710 VIN.n518 VSS 0.01477f ; **FLOATING
C1711 VIN.n519 VSS 0.01477f ; **FLOATING
C1712 VIN.n520 VSS 0.01477f ; **FLOATING
C1713 VIN.n521 VSS 0.01477f ; **FLOATING
C1714 VIN.n522 VSS 0.01477f ; **FLOATING
C1715 VIN.n523 VSS 0.01477f ; **FLOATING
C1716 VIN.n524 VSS 0.01477f ; **FLOATING
C1717 VIN.n525 VSS 0.01477f ; **FLOATING
C1718 VIN.n526 VSS 0.01477f ; **FLOATING
C1719 VIN.n527 VSS 0.01477f ; **FLOATING
C1720 VIN.n528 VSS 0.01477f ; **FLOATING
C1721 VIN.n529 VSS 0.01477f ; **FLOATING
C1722 VIN.n530 VSS 0.01477f ; **FLOATING
C1723 VIN.n531 VSS 0.01477f ; **FLOATING
C1724 VIN.n532 VSS 0.01477f ; **FLOATING
C1725 VIN.n533 VSS 0.01477f ; **FLOATING
C1726 VIN.n534 VSS 0.01477f ; **FLOATING
C1727 VIN.n535 VSS 0.01477f ; **FLOATING
C1728 VIN.n536 VSS 0.01477f ; **FLOATING
C1729 VIN.n537 VSS 0.01477f ; **FLOATING
C1730 VIN.n538 VSS 0.01477f ; **FLOATING
C1731 VIN.n539 VSS 0.01477f ; **FLOATING
C1732 VIN.n540 VSS 0.01477f ; **FLOATING
C1733 VIN.n541 VSS 0.01477f ; **FLOATING
C1734 VIN.n542 VSS 0.01477f ; **FLOATING
C1735 VIN.n543 VSS 0.01477f ; **FLOATING
C1736 VIN.n544 VSS 0.01477f ; **FLOATING
C1737 VIN.n545 VSS 0.01477f ; **FLOATING
C1738 VIN.n546 VSS 0.01477f ; **FLOATING
C1739 VIN.n547 VSS 0.01477f ; **FLOATING
C1740 VIN.n548 VSS 0.01477f ; **FLOATING
C1741 VIN.n549 VSS 0.01477f ; **FLOATING
C1742 VIN.n550 VSS 0.01477f ; **FLOATING
C1743 VIN.n551 VSS 0.01477f ; **FLOATING
C1744 VIN.n552 VSS 0.01477f ; **FLOATING
C1745 VIN.n553 VSS 0.01477f ; **FLOATING
C1746 VIN.n554 VSS 0.01477f ; **FLOATING
C1747 VIN.n555 VSS 0.01477f ; **FLOATING
C1748 VIN.n556 VSS 0.01477f ; **FLOATING
C1749 VIN.n557 VSS 0.01477f ; **FLOATING
C1750 VIN.n558 VSS 0.01477f ; **FLOATING
C1751 VIN.n559 VSS 0.01477f ; **FLOATING
C1752 VIN.n560 VSS 0.01477f ; **FLOATING
C1753 VIN.n561 VSS 0.01477f ; **FLOATING
C1754 VIN.n562 VSS 0.01477f ; **FLOATING
C1755 VIN.n563 VSS 0.01477f ; **FLOATING
C1756 VIN.n564 VSS 0.01477f ; **FLOATING
C1757 VIN.n565 VSS 0.01477f ; **FLOATING
C1758 VIN.n566 VSS 0.01477f ; **FLOATING
C1759 VIN.n567 VSS 2.00108f ; **FLOATING
C1760 VIN.t14 VSS 0.71271f ; **FLOATING
C1761 VIN.t22 VSS 0.71271f ; **FLOATING
C1762 VIN.t34 VSS 0.71271f ; **FLOATING
C1763 VIN.t50 VSS 0.71271f ; **FLOATING
C1764 VIN.t65 VSS 0.29845f ; **FLOATING
C1765 VIN.t79 VSS 0.29845f ; **FLOATING
C1766 VIN.t81 VSS 0.71271f ; **FLOATING
C1767 VIN.t97 VSS 0.51672f ; **FLOATING
C1768 VIN.t104 VSS 0.71271f ; **FLOATING
C1769 VIN.t113 VSS 0.71271f ; **FLOATING
C1770 VIN.t116 VSS 0.71271f ; **FLOATING
C1771 VIN.t258 VSS 0.71271f ; **FLOATING
C1772 VIN.t260 VSS 0.71271f ; **FLOATING
C1773 VIN.t264 VSS 0.71271f ; **FLOATING
C1774 VIN.t328 VSS 0.71271f ; **FLOATING
C1775 VIN.t333 VSS 0.51672f ; **FLOATING
C1776 VIN.t244 VSS 0.71271f ; **FLOATING
C1777 VIN.t242 VSS 0.4499f ; **FLOATING
C1778 VIN.t240 VSS 0.4499f ; **FLOATING
C1779 VIN.t236 VSS 0.71271f ; **FLOATING
C1780 VIN.t232 VSS 0.44545f ; **FLOATING
C1781 VIN.t230 VSS 0.71271f ; **FLOATING
C1782 VIN.t228 VSS 0.71271f ; **FLOATING
C1783 VIN.t226 VSS 0.71271f ; **FLOATING
C1784 VIN.t224 VSS 0.71271f ; **FLOATING
C1785 VIN.t220 VSS 0.44545f ; **FLOATING
C1786 VIN.n568 VSS 0.14503f ; **FLOATING
C1787 VIN.n569 VSS 0.01667f ; **FLOATING
C1788 VIN.t251 VSS 0.53763f ; **FLOATING
C1789 VIN.n570 VSS 0.11598f ; **FLOATING
C1790 VIN.t250 VSS 0.53763f ; **FLOATING
C1791 VIN.n571 VSS 0.11598f ; **FLOATING
C1792 VIN.n572 VSS 0.47876f ; **FLOATING
C1793 VIN.n573 VSS 0.47928f ; **FLOATING
C1794 VIN.n574 VSS 0.06207f ; **FLOATING
C1795 VIN.n575 VSS 0.01997f ; **FLOATING
C1796 VIN.n576 VSS 0.2395f ; **FLOATING
C1797 VIN.t235 VSS 0.44038f ; **FLOATING
C1798 VIN.n577 VSS 0.16162f ; **FLOATING
C1799 VIN.t238 VSS 0.07481f ; **FLOATING
C1800 VIN.t237 VSS 0.06153f ; **FLOATING
C1801 VIN.n578 VSS 0.2273f ; **FLOATING
C1802 VIN.n579 VSS 0.26311f ; **FLOATING
C1803 VIN.t247 VSS 0.44038f ; **FLOATING
C1804 VIN.n580 VSS 0.16162f ; **FLOATING
C1805 VIN.t249 VSS 0.06153f ; **FLOATING
C1806 VIN.n581 VSS 0.2273f ; **FLOATING
C1807 VIN.t248 VSS 0.07481f ; **FLOATING
C1808 VIN.n582 VSS 0.26311f ; **FLOATING
C1809 VIN.t252 VSS 0.44038f ; **FLOATING
C1810 VIN.n583 VSS 0.16162f ; **FLOATING
C1811 VIN.t254 VSS 0.07481f ; **FLOATING
C1812 VIN.t253 VSS 0.06153f ; **FLOATING
C1813 VIN.n584 VSS 0.2273f ; **FLOATING
C1814 VIN.n585 VSS 0.2395f ; **FLOATING
C1815 VIN.t243 VSS 0.44038f ; **FLOATING
C1816 VIN.n586 VSS 0.16162f ; **FLOATING
C1817 VIN.t246 VSS 0.06153f ; **FLOATING
C1818 VIN.n587 VSS 0.2273f ; **FLOATING
C1819 VIN.t245 VSS 0.07481f ; **FLOATING
C1820 VIN.n588 VSS 0.03815f ; **FLOATING
C1821 VIN.n589 VSS 0.08479f ; **FLOATING
C1822 VIN.n590 VSS 1.51739f ; **FLOATING
C1823 VIN.n591 VSS 0.85878f ; **FLOATING
C1824 VIN.n592 VSS 1.20231f ; **FLOATING
C1825 VIN.n593 VSS 0.08479f ; **FLOATING
C1826 VIN.n594 VSS 1.51739f ; **FLOATING
C1827 VIN.n595 VSS 0.85878f ; **FLOATING
C1828 VIN.n596 VSS 1.20231f ; **FLOATING
C1829 VIN.n597 VSS 0.08479f ; **FLOATING
C1830 VIN.n598 VSS 0.08479f ; **FLOATING
C1831 VIN.n599 VSS 0.02052f ; **FLOATING
C1832 VIN.n600 VSS 0.0143f ; **FLOATING
C1833 VIN.n601 VSS 0.02052f ; **FLOATING
C1834 VIN.n602 VSS 0.01648f ; **FLOATING
C1835 VIN.n603 VSS 0.02052f ; **FLOATING
C1836 VIN.n604 VSS 0.02052f ; **FLOATING
C1837 VIN.n605 VSS 0.02052f ; **FLOATING
C1838 VIN.n606 VSS 0.02052f ; **FLOATING
C1839 VIN.n607 VSS 0.02052f ; **FLOATING
C1840 VIN.n608 VSS 0.02052f ; **FLOATING
C1841 VIN.n609 VSS 0.02052f ; **FLOATING
C1842 VIN.n610 VSS 0.02052f ; **FLOATING
C1843 VIN.n611 VSS 0.02052f ; **FLOATING
C1844 VIN.n612 VSS 0.02052f ; **FLOATING
C1845 VIN.n613 VSS 0.02052f ; **FLOATING
C1846 VIN.n614 VSS 0.02052f ; **FLOATING
C1847 VIN.n615 VSS 0.02052f ; **FLOATING
C1848 VIN.n616 VSS 0.0143f ; **FLOATING
C1849 VIN.n617 VSS 0.02052f ; **FLOATING
C1850 VIN.n618 VSS 0.01648f ; **FLOATING
C1851 VIN.n619 VSS 0.02052f ; **FLOATING
C1852 VIN.n620 VSS 0.02052f ; **FLOATING
C1853 VIN.n621 VSS 0.02052f ; **FLOATING
C1854 VIN.n622 VSS 0.02052f ; **FLOATING
C1855 VIN.n623 VSS 0.02052f ; **FLOATING
C1856 VIN.n624 VSS 0.02052f ; **FLOATING
C1857 VIN.n625 VSS 0.02052f ; **FLOATING
C1858 VIN.n626 VSS 0.02052f ; **FLOATING
C1859 VIN.n627 VSS 0.02052f ; **FLOATING
C1860 VIN.n628 VSS 0.02052f ; **FLOATING
C1861 VIN.n629 VSS 0.02052f ; **FLOATING
C1862 VIN.n630 VSS 0.02052f ; **FLOATING
C1863 VIN.n631 VSS 0.02052f ; **FLOATING
C1864 VIN.n632 VSS 0.0143f ; **FLOATING
C1865 VIN.n633 VSS 0.02052f ; **FLOATING
C1866 VIN.n634 VSS 0.01648f ; **FLOATING
C1867 VIN.n635 VSS 0.02052f ; **FLOATING
C1868 VIN.n636 VSS 0.02052f ; **FLOATING
C1869 VIN.n637 VSS 0.02052f ; **FLOATING
C1870 VIN.n638 VSS 0.02052f ; **FLOATING
C1871 VIN.n639 VSS 0.02052f ; **FLOATING
C1872 VIN.n640 VSS 0.02052f ; **FLOATING
C1873 VIN.n641 VSS 0.02052f ; **FLOATING
C1874 VIN.n642 VSS 0.02052f ; **FLOATING
C1875 VIN.n643 VSS 0.02052f ; **FLOATING
C1876 VIN.n644 VSS 0.02052f ; **FLOATING
C1877 VIN.n645 VSS 0.02052f ; **FLOATING
C1878 VIN.n646 VSS 0.02052f ; **FLOATING
C1879 VIN.n647 VSS 0.02052f ; **FLOATING
C1880 VIN.n648 VSS 0.0143f ; **FLOATING
C1881 VIN.n649 VSS 0.02052f ; **FLOATING
C1882 VIN.n650 VSS 0.01648f ; **FLOATING
C1883 VIN.n651 VSS 0.02052f ; **FLOATING
C1884 VIN.n652 VSS 0.02052f ; **FLOATING
C1885 VIN.n653 VSS 0.02052f ; **FLOATING
C1886 VIN.n654 VSS 0.02052f ; **FLOATING
C1887 VIN.n655 VSS 0.02052f ; **FLOATING
C1888 VIN.n656 VSS 0.02052f ; **FLOATING
C1889 VIN.n657 VSS 0.02052f ; **FLOATING
C1890 VIN.n658 VSS 0.02052f ; **FLOATING
C1891 VIN.n659 VSS 0.02052f ; **FLOATING
C1892 VIN.n660 VSS 0.02052f ; **FLOATING
C1893 VIN.n661 VSS 0.02052f ; **FLOATING
C1894 VIN.n662 VSS 0.02052f ; **FLOATING
C1895 VIN.n663 VSS 0.02052f ; **FLOATING
C1896 VIN.n664 VSS 0.0143f ; **FLOATING
C1897 VIN.n665 VSS 0.02052f ; **FLOATING
C1898 VIN.n666 VSS 0.01648f ; **FLOATING
C1899 VIN.n667 VSS 0.02052f ; **FLOATING
C1900 VIN.n668 VSS 0.02052f ; **FLOATING
C1901 VIN.n669 VSS 0.02052f ; **FLOATING
C1902 VIN.n670 VSS 0.02052f ; **FLOATING
C1903 VIN.n671 VSS 0.02052f ; **FLOATING
C1904 VIN.n672 VSS 0.02052f ; **FLOATING
C1905 VIN.n673 VSS 0.02052f ; **FLOATING
C1906 VIN.n674 VSS 0.02052f ; **FLOATING
C1907 VIN.n675 VSS 0.02052f ; **FLOATING
C1908 VIN.n676 VSS 0.02052f ; **FLOATING
C1909 VIN.n677 VSS 0.02052f ; **FLOATING
C1910 VIN.n678 VSS 0.02052f ; **FLOATING
C1911 VIN.n679 VSS 0.02052f ; **FLOATING
C1912 VIN.n680 VSS 0.0143f ; **FLOATING
C1913 VIN.n681 VSS 0.02052f ; **FLOATING
C1914 VIN.n682 VSS 0.01648f ; **FLOATING
C1915 VIN.n683 VSS 0.02052f ; **FLOATING
C1916 VIN.n684 VSS 0.02052f ; **FLOATING
C1917 VIN.n685 VSS 0.02052f ; **FLOATING
C1918 VIN.n686 VSS 0.02052f ; **FLOATING
C1919 VIN.n687 VSS 0.02052f ; **FLOATING
C1920 VIN.n688 VSS 0.02052f ; **FLOATING
C1921 VIN.n689 VSS 0.02052f ; **FLOATING
C1922 VIN.n690 VSS 0.02052f ; **FLOATING
C1923 VIN.n691 VSS 0.02052f ; **FLOATING
C1924 VIN.n692 VSS 0.02052f ; **FLOATING
C1925 VIN.n693 VSS 0.02052f ; **FLOATING
C1926 VIN.n694 VSS 0.02052f ; **FLOATING
C1927 VIN.n695 VSS 0.02052f ; **FLOATING
C1928 VIN.n696 VSS 0.0143f ; **FLOATING
C1929 VIN.n697 VSS 0.02052f ; **FLOATING
C1930 VIN.n698 VSS 0.01648f ; **FLOATING
C1931 VIN.n699 VSS 0.02052f ; **FLOATING
C1932 VIN.n700 VSS 0.02052f ; **FLOATING
C1933 VIN.n701 VSS 0.02052f ; **FLOATING
C1934 VIN.n702 VSS 0.02052f ; **FLOATING
C1935 VIN.n703 VSS 0.02052f ; **FLOATING
C1936 VIN.n704 VSS 0.02052f ; **FLOATING
C1937 VIN.n705 VSS 0.02052f ; **FLOATING
C1938 VIN.n706 VSS 0.02052f ; **FLOATING
C1939 VIN.n707 VSS 0.02052f ; **FLOATING
C1940 VIN.n708 VSS 0.02052f ; **FLOATING
C1941 VIN.n709 VSS 0.02052f ; **FLOATING
C1942 VIN.n710 VSS 0.02052f ; **FLOATING
C1943 VIN.n711 VSS 0.02052f ; **FLOATING
C1944 VIN.n712 VSS 0.02052f ; **FLOATING
C1945 VIN.n713 VSS 0.02052f ; **FLOATING
C1946 VIN.n714 VSS 0.02052f ; **FLOATING
C1947 VIN.n715 VSS 0.02052f ; **FLOATING
C1948 VIN.n716 VSS 0.02052f ; **FLOATING
C1949 VIN.n717 VSS 0.02052f ; **FLOATING
C1950 VIN.n718 VSS 0.02052f ; **FLOATING
C1951 VIN.n719 VSS 0.02052f ; **FLOATING
C1952 VIN.n720 VSS 0.02052f ; **FLOATING
C1953 VIN.n721 VSS 0.02052f ; **FLOATING
C1954 VIN.n722 VSS 0.02052f ; **FLOATING
C1955 VIN.n723 VSS 0.02052f ; **FLOATING
C1956 VIN.n724 VSS 0.02052f ; **FLOATING
C1957 VIN.n725 VSS 0.02052f ; **FLOATING
C1958 VIN.n726 VSS 0.02052f ; **FLOATING
C1959 VIN.n727 VSS 0.02052f ; **FLOATING
C1960 VIN.n728 VSS 0.0143f ; **FLOATING
C1961 VIN.n729 VSS 0.02052f ; **FLOATING
C1962 VIN.n730 VSS 0.01648f ; **FLOATING
C1963 VIN.n731 VSS 0.02052f ; **FLOATING
C1964 VIN.n732 VSS 0.02052f ; **FLOATING
C1965 VIN.n733 VSS 0.02052f ; **FLOATING
C1966 VIN.n734 VSS 0.02052f ; **FLOATING
C1967 VIN.n735 VSS 0.02052f ; **FLOATING
C1968 VIN.n736 VSS 0.02052f ; **FLOATING
C1969 VIN.n737 VSS 0.02052f ; **FLOATING
C1970 VIN.n738 VSS 0.02052f ; **FLOATING
C1971 VIN.n739 VSS 0.02052f ; **FLOATING
C1972 VIN.n740 VSS 0.02052f ; **FLOATING
C1973 VIN.n741 VSS 0.02052f ; **FLOATING
C1974 VIN.n742 VSS 0.02052f ; **FLOATING
C1975 VIN.n743 VSS 0.02052f ; **FLOATING
C1976 VIN.n744 VSS 0.0143f ; **FLOATING
C1977 VIN.n745 VSS 0.02052f ; **FLOATING
C1978 VIN.n746 VSS 0.01648f ; **FLOATING
C1979 VIN.n747 VSS 0.02052f ; **FLOATING
C1980 VIN.n748 VSS 0.02052f ; **FLOATING
C1981 VIN.n749 VSS 0.02052f ; **FLOATING
C1982 VIN.n750 VSS 0.02052f ; **FLOATING
C1983 VIN.n751 VSS 0.02052f ; **FLOATING
C1984 VIN.n752 VSS 0.02052f ; **FLOATING
C1985 VIN.n753 VSS 0.02052f ; **FLOATING
C1986 VIN.n754 VSS 0.02052f ; **FLOATING
C1987 VIN.n755 VSS 0.02052f ; **FLOATING
C1988 VIN.n756 VSS 0.02052f ; **FLOATING
C1989 VIN.n757 VSS 0.02052f ; **FLOATING
C1990 VIN.n758 VSS 0.02052f ; **FLOATING
C1991 VIN.n759 VSS 0.02052f ; **FLOATING
C1992 VIN.n760 VSS 0.0143f ; **FLOATING
C1993 VIN.n761 VSS 0.02052f ; **FLOATING
C1994 VIN.n762 VSS 0.01648f ; **FLOATING
C1995 VIN.n763 VSS 0.02052f ; **FLOATING
C1996 VIN.n764 VSS 0.02052f ; **FLOATING
C1997 VIN.n765 VSS 0.02052f ; **FLOATING
C1998 VIN.n766 VSS 0.02052f ; **FLOATING
C1999 VIN.n767 VSS 0.02052f ; **FLOATING
C2000 VIN.n768 VSS 0.02052f ; **FLOATING
C2001 VIN.n769 VSS 0.02052f ; **FLOATING
C2002 VIN.n770 VSS 0.02052f ; **FLOATING
C2003 VIN.n771 VSS 0.02052f ; **FLOATING
C2004 VIN.n772 VSS 0.02052f ; **FLOATING
C2005 VIN.n773 VSS 0.02052f ; **FLOATING
C2006 VIN.n774 VSS 0.02052f ; **FLOATING
C2007 VIN.n775 VSS 0.02052f ; **FLOATING
C2008 VIN.n776 VSS 0.0143f ; **FLOATING
C2009 VIN.n777 VSS 0.02052f ; **FLOATING
C2010 VIN.n778 VSS 0.01648f ; **FLOATING
C2011 VIN.n779 VSS 0.02052f ; **FLOATING
C2012 VIN.n780 VSS 0.02052f ; **FLOATING
C2013 VIN.n781 VSS 0.02052f ; **FLOATING
C2014 VIN.n782 VSS 0.02052f ; **FLOATING
C2015 VIN.n783 VSS 0.02052f ; **FLOATING
C2016 VIN.n784 VSS 0.02052f ; **FLOATING
C2017 VIN.n785 VSS 0.02052f ; **FLOATING
C2018 VIN.n786 VSS 0.02052f ; **FLOATING
C2019 VIN.n787 VSS 0.02052f ; **FLOATING
C2020 VIN.n788 VSS 0.02052f ; **FLOATING
C2021 VIN.n790 VSS 1.43248f ; **FLOATING
C2022 VIN.n791 VSS 0.40677f ; **FLOATING
C2023 VIN.n792 VSS 0.01667f ; **FLOATING
C2024 VIN.n793 VSS 0.08686f ; **FLOATING
C2025 VIN.n794 VSS 0.02052f ; **FLOATING
C2026 VIN.n795 VSS 0.02052f ; **FLOATING
C2027 VIN.n796 VSS 0.02052f ; **FLOATING
C2028 VIN.n797 VSS 0.02052f ; **FLOATING
C2029 VIN.n798 VSS 0.02052f ; **FLOATING
C2030 VIN.n799 VSS 0.02052f ; **FLOATING
C2031 VIN.n800 VSS 0.02052f ; **FLOATING
C2032 VIN.n801 VSS 0.02052f ; **FLOATING
C2033 VIN.n802 VSS 0.02052f ; **FLOATING
C2034 VIN.n803 VSS 0.02052f ; **FLOATING
C2035 VIN.n804 VSS 0.02052f ; **FLOATING
C2036 VIN.n805 VSS 0.02052f ; **FLOATING
C2037 VIN.n806 VSS 0.02052f ; **FLOATING
C2038 VIN.n807 VSS 0.02052f ; **FLOATING
C2039 VIN.n808 VSS 0.02052f ; **FLOATING
C2040 VIN.n809 VSS 0.02052f ; **FLOATING
C2041 VIN.n810 VSS 0.02052f ; **FLOATING
C2042 VIN.n811 VSS 0.02052f ; **FLOATING
C2043 VIN.n812 VSS 0.02052f ; **FLOATING
C2044 VIN.n813 VSS 0.02052f ; **FLOATING
C2045 VIN.n814 VSS 0.02052f ; **FLOATING
C2046 VIN.n815 VSS 0.02052f ; **FLOATING
C2047 VIN.n816 VSS 0.02052f ; **FLOATING
C2048 VIN.n817 VSS 0.02052f ; **FLOATING
C2049 VIN.n818 VSS 0.02052f ; **FLOATING
C2050 VIN.n819 VSS 0.02052f ; **FLOATING
C2051 VIN.n820 VSS 0.02052f ; **FLOATING
C2052 VIN.n821 VSS 0.02052f ; **FLOATING
C2053 VIN.n822 VSS 0.02052f ; **FLOATING
C2054 VIN.n823 VSS 0.02052f ; **FLOATING
C2055 VIN.n824 VSS 0.02052f ; **FLOATING
C2056 VIN.n825 VSS 0.02052f ; **FLOATING
C2057 VIN.n826 VSS 0.02052f ; **FLOATING
C2058 VIN.n827 VSS 0.02052f ; **FLOATING
C2059 VIN.n828 VSS 0.02052f ; **FLOATING
C2060 VIN.n829 VSS 0.02052f ; **FLOATING
C2061 VIN.n830 VSS 0.02052f ; **FLOATING
C2062 VIN.n831 VSS 0.02052f ; **FLOATING
C2063 VIN.n832 VSS 0.02052f ; **FLOATING
C2064 VIN.n833 VSS 0.02052f ; **FLOATING
C2065 VIN.n834 VSS 0.02052f ; **FLOATING
C2066 VIN.n835 VSS 0.02052f ; **FLOATING
C2067 VIN.n836 VSS 0.02052f ; **FLOATING
C2068 VIN.n837 VSS 0.02052f ; **FLOATING
C2069 VIN.n838 VSS 0.02052f ; **FLOATING
C2070 VIN.n839 VSS 0.02052f ; **FLOATING
C2071 VIN.n840 VSS 0.02052f ; **FLOATING
C2072 VIN.n841 VSS 0.02052f ; **FLOATING
C2073 VIN.n842 VSS 0.02052f ; **FLOATING
C2074 VIN.n843 VSS 0.02052f ; **FLOATING
C2075 VIN.n844 VSS 0.02052f ; **FLOATING
C2076 VIN.n845 VSS 0.02052f ; **FLOATING
C2077 VIN.n846 VSS 0.02052f ; **FLOATING
C2078 VIN.n847 VSS 0.02052f ; **FLOATING
C2079 VIN.n848 VSS 0.02052f ; **FLOATING
C2080 VIN.n849 VSS 0.02052f ; **FLOATING
C2081 VIN.n850 VSS 0.02052f ; **FLOATING
C2082 VIN.n851 VSS 0.02052f ; **FLOATING
C2083 VIN.n852 VSS 0.02052f ; **FLOATING
C2084 VIN.n853 VSS 0.02052f ; **FLOATING
C2085 VIN.n854 VSS 0.02052f ; **FLOATING
C2086 VIN.n855 VSS 0.02052f ; **FLOATING
C2087 VIN.n856 VSS 0.02052f ; **FLOATING
C2088 VIN.n857 VSS 0.02052f ; **FLOATING
C2089 VIN.n858 VSS 0.02052f ; **FLOATING
C2090 VIN.n859 VSS 0.02052f ; **FLOATING
C2091 VIN.n860 VSS 0.02052f ; **FLOATING
C2092 VIN.n861 VSS 0.02052f ; **FLOATING
C2093 VIN.n862 VSS 0.02052f ; **FLOATING
C2094 VIN.n863 VSS 0.02052f ; **FLOATING
C2095 VIN.n864 VSS 0.02052f ; **FLOATING
C2096 VIN.n865 VSS 0.02052f ; **FLOATING
C2097 VIN.n866 VSS 0.02052f ; **FLOATING
C2098 VIN.n867 VSS 0.02052f ; **FLOATING
C2099 VIN.n868 VSS 0.02052f ; **FLOATING
C2100 VIN.n869 VSS 0.02052f ; **FLOATING
C2101 VIN.n870 VSS 0.02052f ; **FLOATING
C2102 VIN.n871 VSS 0.02052f ; **FLOATING
C2103 VIN.n872 VSS 0.02052f ; **FLOATING
C2104 VIN.n873 VSS 0.02052f ; **FLOATING
C2105 VIN.n874 VSS 0.02052f ; **FLOATING
C2106 VIN.n875 VSS 0.02052f ; **FLOATING
C2107 VIN.n876 VSS 0.02052f ; **FLOATING
C2108 VIN.n877 VSS 0.02052f ; **FLOATING
C2109 VIN.n878 VSS 0.02052f ; **FLOATING
C2110 VIN.n879 VSS 0.02052f ; **FLOATING
C2111 VIN.n880 VSS 0.02052f ; **FLOATING
C2112 VIN.n881 VSS 0.02052f ; **FLOATING
C2113 VIN.n882 VSS 0.02052f ; **FLOATING
C2114 VIN.n883 VSS 0.02052f ; **FLOATING
C2115 VIN.n884 VSS 0.02052f ; **FLOATING
C2116 VIN.n885 VSS 0.02052f ; **FLOATING
C2117 VIN.n886 VSS 0.02052f ; **FLOATING
C2118 VIN.n887 VSS 0.02052f ; **FLOATING
C2119 VIN.n888 VSS 0.02052f ; **FLOATING
C2120 VIN.n889 VSS 0.02052f ; **FLOATING
C2121 VIN.n890 VSS 0.02052f ; **FLOATING
C2122 VIN.n891 VSS 0.02052f ; **FLOATING
C2123 VIN.n892 VSS 0.02052f ; **FLOATING
C2124 VIN.n893 VSS 0.02052f ; **FLOATING
C2125 VIN.n894 VSS 0.02052f ; **FLOATING
C2126 VIN.n895 VSS 0.02052f ; **FLOATING
C2127 VIN.n896 VSS 0.02052f ; **FLOATING
C2128 VIN.n897 VSS 0.02052f ; **FLOATING
C2129 VIN.n898 VSS 0.02052f ; **FLOATING
C2130 VIN.n899 VSS 0.02052f ; **FLOATING
C2131 VIN.n900 VSS 0.02052f ; **FLOATING
C2132 VIN.n901 VSS 0.02052f ; **FLOATING
C2133 VIN.n902 VSS 0.02052f ; **FLOATING
C2134 VIN.n903 VSS 0.02052f ; **FLOATING
C2135 VIN.n904 VSS 0.02052f ; **FLOATING
C2136 VIN.n905 VSS 0.02052f ; **FLOATING
C2137 VIN.n906 VSS 0.02052f ; **FLOATING
C2138 VIN.n907 VSS 0.02052f ; **FLOATING
C2139 VIN.n908 VSS 0.02052f ; **FLOATING
C2140 VIN.n909 VSS 0.02052f ; **FLOATING
C2141 VIN.n910 VSS 0.02052f ; **FLOATING
C2142 VIN.n911 VSS 0.02052f ; **FLOATING
C2143 VIN.n912 VSS 0.02052f ; **FLOATING
C2144 VIN.n913 VSS 0.02052f ; **FLOATING
C2145 VIN.n914 VSS 0.02052f ; **FLOATING
C2146 VIN.n915 VSS 0.02052f ; **FLOATING
C2147 VIN.n916 VSS 0.02052f ; **FLOATING
C2148 VIN.n917 VSS 0.02052f ; **FLOATING
C2149 VIN.n918 VSS 0.02052f ; **FLOATING
C2150 VIN.n919 VSS 0.02052f ; **FLOATING
C2151 VIN.n920 VSS 0.02052f ; **FLOATING
C2152 VIN.n921 VSS 0.02052f ; **FLOATING
C2153 VIN.n922 VSS 0.02052f ; **FLOATING
C2154 VIN.n923 VSS 0.02052f ; **FLOATING
C2155 VIN.n924 VSS 0.02052f ; **FLOATING
C2156 VIN.n925 VSS 0.02052f ; **FLOATING
C2157 VIN.n926 VSS 0.02052f ; **FLOATING
C2158 VIN.n927 VSS 0.02052f ; **FLOATING
C2159 VIN.n928 VSS 0.02052f ; **FLOATING
C2160 VIN.n929 VSS 0.02052f ; **FLOATING
C2161 VIN.n930 VSS 0.02052f ; **FLOATING
C2162 VIN.n931 VSS 0.02052f ; **FLOATING
C2163 VIN.n932 VSS 0.02052f ; **FLOATING
C2164 VIN.n933 VSS 0.02052f ; **FLOATING
C2165 VIN.n934 VSS 0.02052f ; **FLOATING
C2166 VIN.n935 VSS 0.02052f ; **FLOATING
C2167 VIN.n936 VSS 0.02052f ; **FLOATING
C2168 VIN.n937 VSS 0.02052f ; **FLOATING
C2169 VIN.n938 VSS 0.02052f ; **FLOATING
C2170 VIN.n939 VSS 0.02052f ; **FLOATING
C2171 VIN.n940 VSS 0.02052f ; **FLOATING
C2172 VIN.n941 VSS 0.02052f ; **FLOATING
C2173 VIN.n942 VSS 0.02052f ; **FLOATING
C2174 VIN.n943 VSS 0.02052f ; **FLOATING
C2175 VIN.n944 VSS 0.02052f ; **FLOATING
C2176 VIN.n945 VSS 0.02052f ; **FLOATING
C2177 VIN.n946 VSS 0.02052f ; **FLOATING
C2178 VIN.n947 VSS 0.02052f ; **FLOATING
C2179 VIN.n948 VSS 0.02052f ; **FLOATING
C2180 VIN.n949 VSS 0.02052f ; **FLOATING
C2181 VIN.n950 VSS 0.02052f ; **FLOATING
C2182 VIN.n951 VSS 0.02052f ; **FLOATING
C2183 VIN.n952 VSS 0.02052f ; **FLOATING
C2184 VIN.n953 VSS 0.02052f ; **FLOATING
C2185 VIN.n954 VSS 0.02052f ; **FLOATING
C2186 VIN.n955 VSS 0.02052f ; **FLOATING
C2187 VIN.n956 VSS 0.02052f ; **FLOATING
C2188 VIN.n957 VSS 0.02052f ; **FLOATING
C2189 VIN.n958 VSS 0.02052f ; **FLOATING
C2190 VIN.n959 VSS 0.02052f ; **FLOATING
C2191 VIN.n960 VSS 0.02052f ; **FLOATING
C2192 VIN.n961 VSS 0.02052f ; **FLOATING
C2193 VIN.n962 VSS 0.02052f ; **FLOATING
C2194 VIN.n963 VSS 0.02052f ; **FLOATING
C2195 VIN.n964 VSS 0.02052f ; **FLOATING
C2196 VIN.n965 VSS 0.02052f ; **FLOATING
C2197 VIN.n966 VSS 0.02052f ; **FLOATING
C2198 VIN.n967 VSS 0.02052f ; **FLOATING
C2199 VIN.n968 VSS 0.02052f ; **FLOATING
C2200 VIN.n969 VSS 0.02052f ; **FLOATING
C2201 VIN.n970 VSS 0.02052f ; **FLOATING
C2202 VIN.n971 VSS 0.02052f ; **FLOATING
C2203 VIN.n972 VSS 0.02052f ; **FLOATING
C2204 VIN.n973 VSS 0.02052f ; **FLOATING
C2205 VIN.n974 VSS 0.02052f ; **FLOATING
C2206 VIN.n975 VSS 0.02052f ; **FLOATING
C2207 VIN.n976 VSS 0.02052f ; **FLOATING
C2208 VIN.n977 VSS 0.02052f ; **FLOATING
C2209 VIN.n978 VSS 0.02052f ; **FLOATING
C2210 VIN.n979 VSS 0.02052f ; **FLOATING
C2211 VIN.n980 VSS 0.02052f ; **FLOATING
C2212 VIN.n981 VSS 0.02052f ; **FLOATING
C2213 VIN.n982 VSS 0.02052f ; **FLOATING
C2214 VIN.n983 VSS 0.02052f ; **FLOATING
C2215 VIN.n984 VSS 0.02052f ; **FLOATING
C2216 VIN.n985 VSS 0.02052f ; **FLOATING
C2217 VIN.n986 VSS 0.02052f ; **FLOATING
C2218 VIN.n987 VSS 0.02052f ; **FLOATING
C2219 VIN.n988 VSS 0.02052f ; **FLOATING
C2220 VIN.n989 VSS 0.02052f ; **FLOATING
C2221 VIN.n990 VSS 0.08686f ; **FLOATING
C2222 VIN.n992 VSS 0.11202f ; **FLOATING
C2223 VIN.n993 VSS 0.01477f ; **FLOATING
C2224 VIN.n994 VSS 0.01477f ; **FLOATING
C2225 VIN.n995 VSS 0.01477f ; **FLOATING
C2226 VIN.n996 VSS 0.01477f ; **FLOATING
C2227 VIN.n997 VSS 0.01477f ; **FLOATING
C2228 VIN.n998 VSS 0.01477f ; **FLOATING
C2229 VIN.n999 VSS 0.01477f ; **FLOATING
C2230 VIN.n1000 VSS 0.01477f ; **FLOATING
C2231 VIN.n1001 VSS 0.01477f ; **FLOATING
C2232 VIN.n1002 VSS 0.01477f ; **FLOATING
C2233 VIN.n1003 VSS 0.01477f ; **FLOATING
C2234 VIN.n1004 VSS 0.01477f ; **FLOATING
C2235 VIN.n1005 VSS 0.01477f ; **FLOATING
C2236 VIN.n1006 VSS 0.01477f ; **FLOATING
C2237 VIN.n1007 VSS 0.01477f ; **FLOATING
C2238 VIN.n1008 VSS 0.01477f ; **FLOATING
C2239 VIN.n1009 VSS 0.01477f ; **FLOATING
C2240 VIN.n1010 VSS 0.01477f ; **FLOATING
C2241 VIN.n1011 VSS 0.01477f ; **FLOATING
C2242 VIN.n1012 VSS 0.01477f ; **FLOATING
C2243 VIN.n1013 VSS 0.01477f ; **FLOATING
C2244 VIN.n1014 VSS 0.01477f ; **FLOATING
C2245 VIN.n1015 VSS 0.01477f ; **FLOATING
C2246 VIN.n1016 VSS 0.01477f ; **FLOATING
C2247 VIN.n1017 VSS 0.01477f ; **FLOATING
C2248 VIN.n1018 VSS 0.01477f ; **FLOATING
C2249 VIN.n1019 VSS 0.01477f ; **FLOATING
C2250 VIN.n1020 VSS 0.01477f ; **FLOATING
C2251 VIN.n1021 VSS 0.01477f ; **FLOATING
C2252 VIN.n1022 VSS 0.01477f ; **FLOATING
C2253 VIN.n1023 VSS 0.01477f ; **FLOATING
C2254 VIN.n1024 VSS 0.01477f ; **FLOATING
C2255 VIN.n1025 VSS 0.01477f ; **FLOATING
C2256 VIN.n1026 VSS 0.01477f ; **FLOATING
C2257 VIN.n1027 VSS 0.01477f ; **FLOATING
C2258 VIN.n1028 VSS 0.01477f ; **FLOATING
C2259 VIN.n1029 VSS 0.01477f ; **FLOATING
C2260 VIN.n1030 VSS 0.01477f ; **FLOATING
C2261 VIN.n1031 VSS 0.01477f ; **FLOATING
C2262 VIN.n1032 VSS 0.01477f ; **FLOATING
C2263 VIN.n1033 VSS 0.01477f ; **FLOATING
C2264 VIN.n1034 VSS 0.01477f ; **FLOATING
C2265 VIN.n1035 VSS 0.01477f ; **FLOATING
C2266 VIN.n1036 VSS 0.01477f ; **FLOATING
C2267 VIN.n1037 VSS 0.01477f ; **FLOATING
C2268 VIN.n1038 VSS 0.01477f ; **FLOATING
C2269 VIN.n1039 VSS 0.01477f ; **FLOATING
C2270 VIN.n1040 VSS 0.01477f ; **FLOATING
C2271 VIN.n1041 VSS 0.01477f ; **FLOATING
C2272 VIN.n1042 VSS 0.01477f ; **FLOATING
C2273 VIN.n1043 VSS 0.01477f ; **FLOATING
C2274 VIN.n1044 VSS 0.01477f ; **FLOATING
C2275 VIN.n1045 VSS 0.01477f ; **FLOATING
C2276 VIN.n1046 VSS 0.01477f ; **FLOATING
C2277 VIN.n1047 VSS 0.01477f ; **FLOATING
C2278 VIN.n1048 VSS 0.01477f ; **FLOATING
C2279 VIN.n1049 VSS 0.01477f ; **FLOATING
C2280 VIN.n1050 VSS 0.01477f ; **FLOATING
C2281 VIN.n1051 VSS 0.01477f ; **FLOATING
C2282 VIN.n1052 VSS 0.01477f ; **FLOATING
C2283 VIN.n1053 VSS 0.01477f ; **FLOATING
C2284 VIN.n1054 VSS 0.01477f ; **FLOATING
C2285 VIN.n1055 VSS 0.01477f ; **FLOATING
C2286 VIN.n1056 VSS 0.01477f ; **FLOATING
C2287 VIN.n1057 VSS 0.01477f ; **FLOATING
C2288 VIN.n1058 VSS 0.01477f ; **FLOATING
C2289 VIN.n1059 VSS 0.01477f ; **FLOATING
C2290 VIN.n1060 VSS 0.01477f ; **FLOATING
C2291 VIN.n1061 VSS 0.01477f ; **FLOATING
C2292 VIN.n1062 VSS 0.01477f ; **FLOATING
C2293 VIN.n1063 VSS 0.01477f ; **FLOATING
C2294 VIN.n1064 VSS 0.01477f ; **FLOATING
C2295 VIN.n1065 VSS 0.01477f ; **FLOATING
C2296 VIN.n1066 VSS 0.01477f ; **FLOATING
C2297 VIN.n1067 VSS 0.01477f ; **FLOATING
C2298 VIN.n1068 VSS 0.01477f ; **FLOATING
C2299 VIN.n1069 VSS 0.01477f ; **FLOATING
C2300 VIN.n1070 VSS 0.01477f ; **FLOATING
C2301 VIN.n1071 VSS 0.01477f ; **FLOATING
C2302 VIN.n1072 VSS 0.01477f ; **FLOATING
C2303 VIN.n1073 VSS 0.01477f ; **FLOATING
C2304 VIN.n1074 VSS 0.01477f ; **FLOATING
C2305 VIN.n1075 VSS 0.01477f ; **FLOATING
C2306 VIN.n1076 VSS 0.01477f ; **FLOATING
C2307 VIN.n1077 VSS 0.01477f ; **FLOATING
C2308 VIN.n1078 VSS 0.01477f ; **FLOATING
C2309 VIN.n1079 VSS 0.01477f ; **FLOATING
C2310 VIN.n1080 VSS 0.01477f ; **FLOATING
C2311 VIN.n1081 VSS 0.01477f ; **FLOATING
C2312 VIN.n1082 VSS 0.01477f ; **FLOATING
C2313 VIN.n1083 VSS 0.01477f ; **FLOATING
C2314 VIN.n1084 VSS 0.01477f ; **FLOATING
C2315 VIN.n1085 VSS 0.01477f ; **FLOATING
C2316 VIN.n1086 VSS 0.01477f ; **FLOATING
C2317 VIN.n1087 VSS 0.01477f ; **FLOATING
C2318 VIN.n1088 VSS 0.01477f ; **FLOATING
C2319 VIN.n1089 VSS 0.01477f ; **FLOATING
C2320 VIN.n1090 VSS 0.01477f ; **FLOATING
C2321 VIN.n1091 VSS 0.11202f ; **FLOATING
C2322 VIN.n1092 VSS 0.01667f ; **FLOATING
C2323 VIN.n1093 VSS 1.17085f ; **FLOATING
C2324 VIN.n1094 VSS 0.11202f ; **FLOATING
C2325 VIN.n1095 VSS 0.83991f ; **FLOATING
C2326 VIN.n1096 VSS 0.01477f ; **FLOATING
C2327 VIN.n1097 VSS 0.64043f ; **FLOATING
C2328 VIN.n1098 VSS 0.01477f ; **FLOATING
C2329 VIN.n1099 VSS 0.58269f ; **FLOATING
C2330 VIN.n1100 VSS 0.01477f ; **FLOATING
C2331 VIN.n1101 VSS 0.4567f ; **FLOATING
C2332 VIN.n1102 VSS 0.01477f ; **FLOATING
C2333 VIN.n1103 VSS 0.54594f ; **FLOATING
C2334 VIN.n1104 VSS 0.01477f ; **FLOATING
C2335 VIN.n1105 VSS 0.58269f ; **FLOATING
C2336 VIN.n1106 VSS 0.01477f ; **FLOATING
C2337 VIN.n1107 VSS 0.55119f ; **FLOATING
C2338 VIN.n1108 VSS 0.01477f ; **FLOATING
C2339 VIN.n1109 VSS 0.45145f ; **FLOATING
C2340 VIN.n1110 VSS 0.01477f ; **FLOATING
C2341 VIN.n1111 VSS 0.58269f ; **FLOATING
C2342 VIN.n1112 VSS 0.01477f ; **FLOATING
C2343 VIN.n1113 VSS 0.58269f ; **FLOATING
C2344 VIN.n1114 VSS 0.01477f ; **FLOATING
C2345 VIN.n1115 VSS 0.48295f ; **FLOATING
C2346 VIN.n1116 VSS 0.01477f ; **FLOATING
C2347 VIN.n1117 VSS 0.51969f ; **FLOATING
C2348 VIN.n1118 VSS 0.01477f ; **FLOATING
C2349 VIN.n1119 VSS 0.58269f ; **FLOATING
C2350 VIN.n1120 VSS 0.01477f ; **FLOATING
C2351 VIN.n1121 VSS 0.57744f ; **FLOATING
C2352 VIN.n1122 VSS 0.01477f ; **FLOATING
C2353 VIN.n1123 VSS 0.4252f ; **FLOATING
C2354 VIN.n1124 VSS 0.01477f ; **FLOATING
C2355 VIN.n1125 VSS 0.58269f ; **FLOATING
C2356 VIN.n1126 VSS 0.01477f ; **FLOATING
C2357 VIN.n1127 VSS 0.58269f ; **FLOATING
C2358 VIN.n1128 VSS 0.01477f ; **FLOATING
C2359 VIN.n1129 VSS 0.5092f ; **FLOATING
C2360 VIN.n1130 VSS 0.01477f ; **FLOATING
C2361 VIN.n1131 VSS 0.49345f ; **FLOATING
C2362 VIN.n1132 VSS 0.01477f ; **FLOATING
C2363 VIN.n1133 VSS 0.58269f ; **FLOATING
C2364 VIN.n1134 VSS 0.01477f ; **FLOATING
C2365 VIN.n1135 VSS 0.58269f ; **FLOATING
C2366 VIN.n1136 VSS 0.01477f ; **FLOATING
C2367 VIN.n1137 VSS 0.44095f ; **FLOATING
C2368 VIN.n1138 VSS 0.01477f ; **FLOATING
C2369 VIN.n1139 VSS 0.56169f ; **FLOATING
C2370 VIN.n1140 VSS 0.01477f ; **FLOATING
C2371 VIN.n1141 VSS 0.58269f ; **FLOATING
C2372 VIN.n1142 VSS 0.01477f ; **FLOATING
C2373 VIN.n1143 VSS 0.53544f ; **FLOATING
C2374 VIN.n1144 VSS 0.01477f ; **FLOATING
C2375 VIN.n1145 VSS 0.4672f ; **FLOATING
C2376 VIN.n1146 VSS 0.01477f ; **FLOATING
C2377 VIN.n1147 VSS 0.58269f ; **FLOATING
C2378 VIN.n1148 VSS 0.01477f ; **FLOATING
C2379 VIN.n1149 VSS 0.58269f ; **FLOATING
C2380 VIN.n1150 VSS 0.01477f ; **FLOATING
C2381 VIN.n1151 VSS 0.4672f ; **FLOATING
C2382 VIN.n1152 VSS 0.01477f ; **FLOATING
C2383 VIN.n1153 VSS 0.53544f ; **FLOATING
C2384 VIN.n1154 VSS 0.01477f ; **FLOATING
C2385 VIN.n1155 VSS 0.58269f ; **FLOATING
C2386 VIN.n1156 VSS 0.01477f ; **FLOATING
C2387 VIN.n1157 VSS 0.56169f ; **FLOATING
C2388 VIN.n1158 VSS 0.01477f ; **FLOATING
C2389 VIN.n1159 VSS 0.44095f ; **FLOATING
C2390 VIN.n1160 VSS 0.01477f ; **FLOATING
C2391 VIN.n1161 VSS 0.58269f ; **FLOATING
C2392 VIN.n1162 VSS 0.01477f ; **FLOATING
C2393 VIN.n1163 VSS 0.58269f ; **FLOATING
C2394 VIN.n1164 VSS 0.01477f ; **FLOATING
C2395 VIN.n1165 VSS 0.49345f ; **FLOATING
C2396 VIN.n1166 VSS 0.01477f ; **FLOATING
C2397 VIN.n1167 VSS 0.5092f ; **FLOATING
C2398 VIN.n1168 VSS 0.01477f ; **FLOATING
C2399 VIN.n1169 VSS 0.58269f ; **FLOATING
C2400 VIN.n1170 VSS 0.01477f ; **FLOATING
C2401 VIN.n1171 VSS 0.58269f ; **FLOATING
C2402 VIN.n1172 VSS 0.01477f ; **FLOATING
C2403 VIN.n1173 VSS 0.4252f ; **FLOATING
C2404 VIN.n1174 VSS 0.01477f ; **FLOATING
C2405 VIN.n1175 VSS 0.57744f ; **FLOATING
C2406 VIN.n1176 VSS 0.01477f ; **FLOATING
C2407 VIN.n1177 VSS 0.58269f ; **FLOATING
C2408 VIN.n1178 VSS 0.01477f ; **FLOATING
C2409 VIN.n1179 VSS 0.51969f ; **FLOATING
C2410 VIN.n1180 VSS 0.01477f ; **FLOATING
C2411 VIN.n1181 VSS 0.48295f ; **FLOATING
C2412 VIN.n1182 VSS 0.01477f ; **FLOATING
C2413 VIN.n1183 VSS 0.58269f ; **FLOATING
C2414 VIN.n1184 VSS 0.01477f ; **FLOATING
C2415 VIN.n1185 VSS 0.58269f ; **FLOATING
C2416 VIN.n1186 VSS 0.01477f ; **FLOATING
C2417 VIN.n1187 VSS 0.45145f ; **FLOATING
C2418 VIN.n1188 VSS 0.01477f ; **FLOATING
C2419 VIN.n1189 VSS 0.55119f ; **FLOATING
C2420 VIN.n1190 VSS 0.01477f ; **FLOATING
C2421 VIN.n1191 VSS 0.58269f ; **FLOATING
C2422 VIN.n1192 VSS 0.01477f ; **FLOATING
C2423 VIN.n1193 VSS 0.54594f ; **FLOATING
C2424 VIN.n1194 VSS 0.01477f ; **FLOATING
C2425 VIN.n1195 VSS 0.4567f ; **FLOATING
C2426 VIN.n1196 VSS 0.01477f ; **FLOATING
C2427 VIN.n1197 VSS 0.58269f ; **FLOATING
C2428 VIN.n1198 VSS 0.01477f ; **FLOATING
C2429 VIN.n1199 VSS 0.58269f ; **FLOATING
C2430 VIN.n1200 VSS 0.01477f ; **FLOATING
C2431 VIN.n1201 VSS 0.4777f ; **FLOATING
C2432 VIN.n1202 VSS 0.01477f ; **FLOATING
C2433 VIN.n1203 VSS 0.52494f ; **FLOATING
C2434 VIN.n1204 VSS 0.01477f ; **FLOATING
C2435 VIN.n1205 VSS 0.58269f ; **FLOATING
C2436 VIN.n1206 VSS 0.01477f ; **FLOATING
C2437 VIN.n1207 VSS 0.57219f ; **FLOATING
C2438 VIN.n1208 VSS 0.01477f ; **FLOATING
C2439 VIN.n1209 VSS 0.43045f ; **FLOATING
C2440 VIN.n1210 VSS 0.01477f ; **FLOATING
C2441 VIN.n1211 VSS 0.58269f ; **FLOATING
C2442 VIN.n1212 VSS 0.01477f ; **FLOATING
C2443 VIN.n1213 VSS 0.58269f ; **FLOATING
C2444 VIN.n1214 VSS 0.01477f ; **FLOATING
C2445 VIN.n1215 VSS 0.50395f ; **FLOATING
C2446 VIN.n1216 VSS 0.01477f ; **FLOATING
C2447 VIN.n1217 VSS 0.4987f ; **FLOATING
C2448 VIN.n1218 VSS 0.01477f ; **FLOATING
C2449 VIN.n1219 VSS 0.58269f ; **FLOATING
C2450 VIN.n1220 VSS 0.01477f ; **FLOATING
C2451 VIN.n1221 VSS 0.58269f ; **FLOATING
C2452 VIN.n1222 VSS 0.01477f ; **FLOATING
C2453 VIN.n1223 VSS 0.4357f ; **FLOATING
C2454 VIN.n1224 VSS 0.01477f ; **FLOATING
C2455 VIN.n1225 VSS 0.56694f ; **FLOATING
C2456 VIN.n1226 VSS 0.01477f ; **FLOATING
C2457 VIN.n1227 VSS 0.58269f ; **FLOATING
C2458 VIN.n1228 VSS 0.01477f ; **FLOATING
C2459 VIN.n1229 VSS 0.53019f ; **FLOATING
C2460 VIN.n1230 VSS 0.01477f ; **FLOATING
C2461 VIN.n1231 VSS 0.47245f ; **FLOATING
C2462 VIN.n1232 VSS 0.01477f ; **FLOATING
C2463 VIN.n1233 VSS 0.58269f ; **FLOATING
C2464 VIN.n1234 VSS 0.01477f ; **FLOATING
C2465 VIN.n1235 VSS 0.58269f ; **FLOATING
C2466 VIN.n1236 VSS 0.01477f ; **FLOATING
C2467 VIN.n1237 VSS 0.46195f ; **FLOATING
C2468 VIN.n1238 VSS 0.01477f ; **FLOATING
C2469 VIN.n1239 VSS 0.54069f ; **FLOATING
C2470 VIN.n1240 VSS 0.01477f ; **FLOATING
C2471 VIN.n1241 VSS 0.58269f ; **FLOATING
C2472 VIN.n1242 VSS 0.01477f ; **FLOATING
C2473 VIN.n1243 VSS 0.55644f ; **FLOATING
C2474 VIN.n1244 VSS 0.01477f ; **FLOATING
C2475 VIN.n1245 VSS 0.4462f ; **FLOATING
C2476 VIN.n1246 VSS 0.01477f ; **FLOATING
C2477 VIN.n1247 VSS 0.58269f ; **FLOATING
C2478 VIN.n1248 VSS 0.01477f ; **FLOATING
C2479 VIN.n1249 VSS 0.58269f ; **FLOATING
C2480 VIN.n1250 VSS 0.01477f ; **FLOATING
C2481 VIN.n1251 VSS 0.4882f ; **FLOATING
C2482 VIN.n1252 VSS 0.01477f ; **FLOATING
C2483 VIN.n1253 VSS 0.51445f ; **FLOATING
C2484 VIN.n1254 VSS 0.01477f ; **FLOATING
C2485 VIN.n1255 VSS 0.58269f ; **FLOATING
C2486 VIN.n1256 VSS 0.01477f ; **FLOATING
C2487 VIN.n1257 VSS 0.58269f ; **FLOATING
C2488 VIN.n1258 VSS 0.01477f ; **FLOATING
C2489 VIN.t41 VSS 0.83991f ; **FLOATING
C2490 VIN.n1259 VSS 0.01477f ; **FLOATING
C2491 VIN.n1260 VSS 0.58269f ; **FLOATING
C2492 VIN.n1261 VSS 0.01477f ; **FLOATING
C2493 VIN.n1262 VSS 0.58269f ; **FLOATING
C2494 VIN.n1263 VSS 0.01477f ; **FLOATING
C2495 VIN.n1264 VSS 0.51445f ; **FLOATING
C2496 VIN.n1265 VSS 0.01477f ; **FLOATING
C2497 VIN.n1266 VSS 0.4882f ; **FLOATING
C2498 VIN.n1267 VSS 0.01477f ; **FLOATING
C2499 VIN.n1268 VSS 0.58269f ; **FLOATING
C2500 VIN.n1269 VSS 0.01477f ; **FLOATING
C2501 VIN.n1270 VSS 0.58269f ; **FLOATING
C2502 VIN.n1271 VSS 0.01477f ; **FLOATING
C2503 VIN.n1272 VSS 0.4462f ; **FLOATING
C2504 VIN.n1273 VSS 0.01477f ; **FLOATING
C2505 VIN.n1274 VSS 0.55644f ; **FLOATING
C2506 VIN.n1275 VSS 0.01477f ; **FLOATING
C2507 VIN.n1276 VSS 0.58269f ; **FLOATING
C2508 VIN.n1277 VSS 0.01477f ; **FLOATING
C2509 VIN.n1278 VSS 0.54069f ; **FLOATING
C2510 VIN.n1279 VSS 0.01477f ; **FLOATING
C2511 VIN.n1280 VSS 0.46195f ; **FLOATING
C2512 VIN.n1281 VSS 0.01477f ; **FLOATING
C2513 VIN.n1282 VSS 0.58269f ; **FLOATING
C2514 VIN.n1283 VSS 0.01477f ; **FLOATING
C2515 VIN.n1284 VSS 0.58269f ; **FLOATING
C2516 VIN.n1285 VSS 0.01477f ; **FLOATING
C2517 VIN.n1286 VSS 0.47245f ; **FLOATING
C2518 VIN.n1287 VSS 0.01477f ; **FLOATING
C2519 VIN.n1288 VSS 0.53019f ; **FLOATING
C2520 VIN.n1289 VSS 0.01477f ; **FLOATING
C2521 VIN.n1290 VSS 1.06061f ; **FLOATING
C2522 VIN.t39 VSS 0.41995f ; **FLOATING
C2523 VIN.t118 VSS 0.41995f ; **FLOATING
C2524 VIN.t133 VSS 0.41995f ; **FLOATING
C2525 VIN.t102 VSS 0.41995f ; **FLOATING
C2526 VIN.t77 VSS 0.41995f ; **FLOATING
C2527 VIN.t129 VSS 0.41995f ; **FLOATING
C2528 VIN.t85 VSS 0.41995f ; **FLOATING
C2529 VIN.t87 VSS 0.41995f ; **FLOATING
C2530 VIN.t125 VSS 0.41995f ; **FLOATING
C2531 VIN.t127 VSS 0.41995f ; **FLOATING
C2532 VIN.t89 VSS 0.41995f ; **FLOATING
C2533 VIN.t149 VSS 0.41995f ; **FLOATING
C2534 VIN.t107 VSS 0.41995f ; **FLOATING
C2535 VIN.t109 VSS 0.41995f ; **FLOATING
C2536 VIN.t100 VSS 0.41995f ; **FLOATING
C2537 VIN.t154 VSS 0.41995f ; **FLOATING
C2538 VIN.t26 VSS 0.41995f ; **FLOATING
C2539 VIN.t157 VSS 0.41995f ; **FLOATING
C2540 VIN.t159 VSS 0.41995f ; **FLOATING
C2541 VIN.t98 VSS 0.41995f ; **FLOATING
C2542 VIN.t162 VSS 0.41995f ; **FLOATING
C2543 VIN.t164 VSS 0.41995f ; **FLOATING
C2544 VIN.t51 VSS 0.41995f ; **FLOATING
C2545 VIN.t114 VSS 0.41995f ; **FLOATING
C2546 VIN.t17 VSS 0.41995f ; **FLOATING
C2547 VIN.t169 VSS 0.41995f ; **FLOATING
C2548 VIN.t171 VSS 0.41995f ; **FLOATING
C2549 VIN.t173 VSS 0.41995f ; **FLOATING
C2550 VIN.t175 VSS 0.41995f ; **FLOATING
C2551 VIN.t95 VSS 0.41995f ; **FLOATING
C2552 VIN.t36 VSS 0.41995f ; **FLOATING
C2553 VIN.t71 VSS 0.41995f ; **FLOATING
C2554 VIN.t138 VSS 0.41995f ; **FLOATING
C2555 VIN.t73 VSS 0.41995f ; **FLOATING
C2556 VIN.t63 VSS 0.41995f ; **FLOATING
C2557 VIN.t183 VSS 0.41995f ; **FLOATING
C2558 VIN.t45 VSS 0.41995f ; **FLOATING
C2559 VIN.t32 VSS 0.41995f ; **FLOATING
C2560 VIN.t187 VSS 0.41995f ; **FLOATING
C2561 VIN.t189 VSS 0.41995f ; **FLOATING
C2562 VIN.t12 VSS 0.41995f ; **FLOATING
C2563 VIN.t30 VSS 0.41995f ; **FLOATING
C2564 VIN.t193 VSS 0.41995f ; **FLOATING
C2565 VIN.t2 VSS 0.41995f ; **FLOATING
C2566 VIN.t48 VSS 0.41995f ; **FLOATING
C2567 VIN.t197 VSS 0.41995f ; **FLOATING
C2568 VIN.t61 VSS 0.41995f ; **FLOATING
C2569 VIN.t24 VSS 0.41995f ; **FLOATING
C2570 VIN.t15 VSS 0.41995f ; **FLOATING
C2571 VIN.t202 VSS 0.41995f ; **FLOATING
C2572 VIN.t43 VSS 0.41995f ; **FLOATING
C2573 VIN.t10 VSS 0.41995f ; **FLOATING
C2574 VIN.t4 VSS 0.41995f ; **FLOATING
C2575 VIN.t91 VSS 0.41995f ; **FLOATING
C2576 VIN.t75 VSS 0.41995f ; **FLOATING
C2577 VIN.t6 VSS 0.41995f ; **FLOATING
C2578 VIN.t83 VSS 0.41995f ; **FLOATING
C2579 VIN.t0 VSS 0.41995f ; **FLOATING
C2580 VIN.t20 VSS 0.41995f ; **FLOATING
C2581 VIN.t93 VSS 0.41995f ; **FLOATING
C2582 VIN.t122 VSS 0.41995f ; **FLOATING
C2583 VIN.t53 VSS 0.41995f ; **FLOATING
C2584 VIN.t58 VSS 0.41995f ; **FLOATING
C2585 VIN.t8 VSS 0.41995f ; **FLOATING
C2586 VIN.t120 VSS 0.41995f ; **FLOATING
C2587 VIN.t290 VSS 0.41995f ; **FLOATING
C2588 VIN.t105 VSS 0.41995f ; **FLOATING
C2589 VIN.t28 VSS 0.41995f ; **FLOATING
C2590 VIN.t319 VSS 0.41995f ; **FLOATING
C2591 VIN.n1291 VSS 0.11202f ; **FLOATING
C2592 VIN.n1292 VSS 0.01667f ; **FLOATING
C2593 VIN.n1293 VSS 1.43248f ; **FLOATING
C2594 VIN.n1294 VSS 0.40677f ; **FLOATING
C2595 VIN.n1295 VSS 0.08479f ; **FLOATING
C2596 VIN.n1296 VSS 0.85878f ; **FLOATING
C2597 VIN.n1297 VSS 1.20231f ; **FLOATING
C2598 VIN.n1298 VSS 1.51739f ; **FLOATING
C2599 VIN.n1299 VSS 0.0618f ; **FLOATING
C2600 VIN.t145 VSS 0.02154f ; **FLOATING
C2601 VIN.t144 VSS 0.02154f ; **FLOATING
C2602 VIN.n1300 VSS 0.18683f ; **FLOATING
C2603 VIN.n1301 VSS 0.091f ; **FLOATING
C2604 VIN.t212 VSS 0.02154f ; **FLOATING
C2605 VIN.t211 VSS 0.02154f ; **FLOATING
C2606 VIN.n1302 VSS 0.18683f ; **FLOATING
C2607 VIN.n1303 VSS 0.08549f ; **FLOATING
C2608 VIN.t210 VSS 0.02154f ; **FLOATING
C2609 VIN.t209 VSS 0.02154f ; **FLOATING
C2610 VIN.n1304 VSS 0.18683f ; **FLOATING
C2611 VIN.n1305 VSS 0.06805f ; **FLOATING
C2612 VIN.t152 VSS 0.02154f ; **FLOATING
C2613 VIN.t151 VSS 0.02154f ; **FLOATING
C2614 VIN.n1306 VSS 0.18683f ; **FLOATING
C2615 VIN.n1307 VSS 0.091f ; **FLOATING
C2616 VIN.t150 VSS 0.02154f ; **FLOATING
C2617 VIN.t148 VSS 0.02154f ; **FLOATING
C2618 VIN.n1308 VSS 0.18683f ; **FLOATING
C2619 VIN.n1309 VSS 0.08215f ; **FLOATING
C2620 VIN.t158 VSS 0.02154f ; **FLOATING
C2621 VIN.t156 VSS 0.02154f ; **FLOATING
C2622 VIN.n1310 VSS 0.18683f ; **FLOATING
C2623 VIN.n1311 VSS 0.07138f ; **FLOATING
C2624 VIN.t155 VSS 0.02154f ; **FLOATING
C2625 VIN.t153 VSS 0.02154f ; **FLOATING
C2626 VIN.n1312 VSS 0.18683f ; **FLOATING
C2627 VIN.n1313 VSS 0.091f ; **FLOATING
C2628 VIN.t165 VSS 0.02154f ; **FLOATING
C2629 VIN.t163 VSS 0.02154f ; **FLOATING
C2630 VIN.n1314 VSS 0.18683f ; **FLOATING
C2631 VIN.n1315 VSS 0.07882f ; **FLOATING
C2632 VIN.t161 VSS 0.02154f ; **FLOATING
C2633 VIN.t160 VSS 0.02154f ; **FLOATING
C2634 VIN.n1316 VSS 0.18683f ; **FLOATING
C2635 VIN.n1317 VSS 0.07472f ; **FLOATING
C2636 VIN.t170 VSS 0.02154f ; **FLOATING
C2637 VIN.t168 VSS 0.02154f ; **FLOATING
C2638 VIN.n1318 VSS 0.18683f ; **FLOATING
C2639 VIN.n1319 VSS 0.091f ; **FLOATING
C2640 VIN.t167 VSS 0.02154f ; **FLOATING
C2641 VIN.t166 VSS 0.02154f ; **FLOATING
C2642 VIN.n1320 VSS 0.18683f ; **FLOATING
C2643 VIN.n1321 VSS 0.07549f ; **FLOATING
C2644 VIN.t338 VSS 0.02154f ; **FLOATING
C2645 VIN.t337 VSS 0.02154f ; **FLOATING
C2646 VIN.n1322 VSS 0.18683f ; **FLOATING
C2647 VIN.n1323 VSS 0.07805f ; **FLOATING
C2648 VIN.t336 VSS 0.02154f ; **FLOATING
C2649 VIN.t335 VSS 0.02154f ; **FLOATING
C2650 VIN.n1324 VSS 0.18683f ; **FLOATING
C2651 VIN.n1325 VSS 0.091f ; **FLOATING
C2652 VIN.t177 VSS 0.02154f ; **FLOATING
C2653 VIN.t176 VSS 0.02154f ; **FLOATING
C2654 VIN.n1326 VSS 0.18683f ; **FLOATING
C2655 VIN.n1327 VSS 0.07215f ; **FLOATING
C2656 VIN.t174 VSS 0.02154f ; **FLOATING
C2657 VIN.t172 VSS 0.02154f ; **FLOATING
C2658 VIN.n1328 VSS 0.18683f ; **FLOATING
C2659 VIN.n1329 VSS 0.08139f ; **FLOATING
C2660 VIN.t181 VSS 0.02154f ; **FLOATING
C2661 VIN.t180 VSS 0.02154f ; **FLOATING
C2662 VIN.n1330 VSS 0.18683f ; **FLOATING
C2663 VIN.n1331 VSS 0.091f ; **FLOATING
C2664 VIN.t179 VSS 0.02154f ; **FLOATING
C2665 VIN.t178 VSS 0.02154f ; **FLOATING
C2666 VIN.n1332 VSS 0.18683f ; **FLOATING
C2667 VIN.n1333 VSS 0.06882f ; **FLOATING
C2668 VIN.t186 VSS 0.02154f ; **FLOATING
C2669 VIN.t185 VSS 0.02154f ; **FLOATING
C2670 VIN.n1334 VSS 0.18683f ; **FLOATING
C2671 VIN.n1335 VSS 0.08472f ; **FLOATING
C2672 VIN.t184 VSS 0.02154f ; **FLOATING
C2673 VIN.t182 VSS 0.02154f ; **FLOATING
C2674 VIN.n1336 VSS 0.18683f ; **FLOATING
C2675 VIN.n1337 VSS 0.091f ; **FLOATING
C2676 VIN.t136 VSS 0.02154f ; **FLOATING
C2677 VIN.t135 VSS 0.02154f ; **FLOATING
C2678 VIN.n1338 VSS 0.18683f ; **FLOATING
C2679 VIN.n1339 VSS 0.06549f ; **FLOATING
C2680 VIN.t134 VSS 0.02154f ; **FLOATING
C2681 VIN.t132 VSS 0.02154f ; **FLOATING
C2682 VIN.n1340 VSS 0.18683f ; **FLOATING
C2683 VIN.n1341 VSS 0.08805f ; **FLOATING
C2684 VIN.t192 VSS 0.02154f ; **FLOATING
C2685 VIN.t191 VSS 0.02154f ; **FLOATING
C2686 VIN.n1342 VSS 0.18683f ; **FLOATING
C2687 VIN.n1343 VSS 0.09062f ; **FLOATING
C2688 VIN.t190 VSS 0.02154f ; **FLOATING
C2689 VIN.t188 VSS 0.02154f ; **FLOATING
C2690 VIN.n1344 VSS 0.18683f ; **FLOATING
C2691 VIN.n1345 VSS 0.06292f ; **FLOATING
C2692 VIN.t198 VSS 0.02154f ; **FLOATING
C2693 VIN.t196 VSS 0.02154f ; **FLOATING
C2694 VIN.n1346 VSS 0.18683f ; **FLOATING
C2695 VIN.n1347 VSS 0.091f ; **FLOATING
C2696 VIN.t195 VSS 0.02154f ; **FLOATING
C2697 VIN.t194 VSS 0.02154f ; **FLOATING
C2698 VIN.n1348 VSS 0.18683f ; **FLOATING
C2699 VIN.n1349 VSS 0.08728f ; **FLOATING
C2700 VIN.t203 VSS 0.02154f ; **FLOATING
C2701 VIN.t201 VSS 0.02154f ; **FLOATING
C2702 VIN.n1350 VSS 0.18683f ; **FLOATING
C2703 VIN.n1351 VSS 0.06625f ; **FLOATING
C2704 VIN.t200 VSS 0.02154f ; **FLOATING
C2705 VIN.t199 VSS 0.02154f ; **FLOATING
C2706 VIN.n1352 VSS 0.18683f ; **FLOATING
C2707 VIN.n1353 VSS 0.091f ; **FLOATING
C2708 VIN.t207 VSS 0.02154f ; **FLOATING
C2709 VIN.t206 VSS 0.02154f ; **FLOATING
C2710 VIN.n1354 VSS 0.18683f ; **FLOATING
C2711 VIN.n1355 VSS 0.08395f ; **FLOATING
C2712 VIN.t205 VSS 0.02154f ; **FLOATING
C2713 VIN.t204 VSS 0.02154f ; **FLOATING
C2714 VIN.n1356 VSS 0.18683f ; **FLOATING
C2715 VIN.n1357 VSS 0.06959f ; **FLOATING
C2716 VIN.t301 VSS 0.02154f ; **FLOATING
C2717 VIN.t300 VSS 0.02154f ; **FLOATING
C2718 VIN.n1358 VSS 0.18683f ; **FLOATING
C2719 VIN.n1359 VSS 0.091f ; **FLOATING
C2720 VIN.t299 VSS 0.02154f ; **FLOATING
C2721 VIN.t298 VSS 0.02154f ; **FLOATING
C2722 VIN.n1360 VSS 0.18683f ; **FLOATING
C2723 VIN.n1361 VSS 0.08062f ; **FLOATING
C2724 VIN.t308 VSS 0.02154f ; **FLOATING
C2725 VIN.t307 VSS 0.02154f ; **FLOATING
C2726 VIN.n1362 VSS 0.18683f ; **FLOATING
C2727 VIN.n1363 VSS 0.07292f ; **FLOATING
C2728 VIN.t306 VSS 0.02154f ; **FLOATING
C2729 VIN.t305 VSS 0.02154f ; **FLOATING
C2730 VIN.n1364 VSS 0.18683f ; **FLOATING
C2731 VIN.n1365 VSS 0.17599f ; **FLOATING
C2732 VIN.t131 VSS 0.22003f ; **FLOATING
C2733 VIN.n1366 VSS 0.0618f ; **FLOATING
C2734 VIN.n1367 VSS 1.51739f ; **FLOATING
C2735 VIN.n1368 VSS 1.20231f ; **FLOATING
C2736 VIN.n1369 VSS 0.85878f ; **FLOATING
C2737 VIN.n1370 VSS 0.0618f ; **FLOATING
C2738 VIN.t88 VSS 0.02154f ; **FLOATING
C2739 VIN.t86 VSS 0.02154f ; **FLOATING
C2740 VIN.n1371 VSS 0.18683f ; **FLOATING
C2741 VIN.n1372 VSS 0.091f ; **FLOATING
C2742 VIN.t84 VSS 0.02154f ; **FLOATING
C2743 VIN.t82 VSS 0.02154f ; **FLOATING
C2744 VIN.n1373 VSS 0.18683f ; **FLOATING
C2745 VIN.n1374 VSS 0.08549f ; **FLOATING
C2746 VIN.t112 VSS 0.02154f ; **FLOATING
C2747 VIN.t111 VSS 0.02154f ; **FLOATING
C2748 VIN.n1375 VSS 0.18683f ; **FLOATING
C2749 VIN.n1376 VSS 0.06805f ; **FLOATING
C2750 VIN.t110 VSS 0.02154f ; **FLOATING
C2751 VIN.t108 VSS 0.02154f ; **FLOATING
C2752 VIN.n1377 VSS 0.18683f ; **FLOATING
C2753 VIN.n1378 VSS 0.091f ; **FLOATING
C2754 VIN.t275 VSS 0.02154f ; **FLOATING
C2755 VIN.t274 VSS 0.02154f ; **FLOATING
C2756 VIN.n1379 VSS 0.18683f ; **FLOATING
C2757 VIN.n1380 VSS 0.08215f ; **FLOATING
C2758 VIN.t273 VSS 0.02154f ; **FLOATING
C2759 VIN.t272 VSS 0.02154f ; **FLOATING
C2760 VIN.n1381 VSS 0.18683f ; **FLOATING
C2761 VIN.n1382 VSS 0.07138f ; **FLOATING
C2762 VIN.t326 VSS 0.02154f ; **FLOATING
C2763 VIN.t325 VSS 0.02154f ; **FLOATING
C2764 VIN.n1383 VSS 0.18683f ; **FLOATING
C2765 VIN.n1384 VSS 0.091f ; **FLOATING
C2766 VIN.t324 VSS 0.02154f ; **FLOATING
C2767 VIN.t323 VSS 0.02154f ; **FLOATING
C2768 VIN.n1385 VSS 0.18683f ; **FLOATING
C2769 VIN.n1386 VSS 0.07882f ; **FLOATING
C2770 VIN.t343 VSS 0.02154f ; **FLOATING
C2771 VIN.t342 VSS 0.02154f ; **FLOATING
C2772 VIN.n1387 VSS 0.18683f ; **FLOATING
C2773 VIN.n1388 VSS 0.07472f ; **FLOATING
C2774 VIN.t341 VSS 0.02154f ; **FLOATING
C2775 VIN.t340 VSS 0.02154f ; **FLOATING
C2776 VIN.n1389 VSS 0.18683f ; **FLOATING
C2777 VIN.n1390 VSS 0.091f ; **FLOATING
C2778 VIN.t322 VSS 0.02154f ; **FLOATING
C2779 VIN.t321 VSS 0.02154f ; **FLOATING
C2780 VIN.n1391 VSS 0.18683f ; **FLOATING
C2781 VIN.n1392 VSS 0.07549f ; **FLOATING
C2782 VIN.t320 VSS 0.02154f ; **FLOATING
C2783 VIN.t318 VSS 0.02154f ; **FLOATING
C2784 VIN.n1393 VSS 0.18683f ; **FLOATING
C2785 VIN.n1394 VSS 0.07805f ; **FLOATING
C2786 VIN.t317 VSS 0.02154f ; **FLOATING
C2787 VIN.t316 VSS 0.02154f ; **FLOATING
C2788 VIN.n1395 VSS 0.18683f ; **FLOATING
C2789 VIN.n1396 VSS 0.091f ; **FLOATING
C2790 VIN.t315 VSS 0.02154f ; **FLOATING
C2791 VIN.t314 VSS 0.02154f ; **FLOATING
C2792 VIN.n1397 VSS 0.18683f ; **FLOATING
C2793 VIN.n1398 VSS 0.07215f ; **FLOATING
C2794 VIN.t284 VSS 0.02154f ; **FLOATING
C2795 VIN.t283 VSS 0.02154f ; **FLOATING
C2796 VIN.n1399 VSS 0.18683f ; **FLOATING
C2797 VIN.n1400 VSS 0.08139f ; **FLOATING
C2798 VIN.t282 VSS 0.02154f ; **FLOATING
C2799 VIN.t281 VSS 0.02154f ; **FLOATING
C2800 VIN.n1401 VSS 0.18683f ; **FLOATING
C2801 VIN.n1402 VSS 0.091f ; **FLOATING
C2802 VIN.t72 VSS 0.02154f ; **FLOATING
C2803 VIN.t70 VSS 0.02154f ; **FLOATING
C2804 VIN.n1403 VSS 0.18683f ; **FLOATING
C2805 VIN.n1404 VSS 0.06882f ; **FLOATING
C2806 VIN.t69 VSS 0.02154f ; **FLOATING
C2807 VIN.t68 VSS 0.02154f ; **FLOATING
C2808 VIN.n1405 VSS 0.18683f ; **FLOATING
C2809 VIN.n1406 VSS 0.08472f ; **FLOATING
C2810 VIN.t347 VSS 0.02154f ; **FLOATING
C2811 VIN.t346 VSS 0.02154f ; **FLOATING
C2812 VIN.n1407 VSS 0.18683f ; **FLOATING
C2813 VIN.n1408 VSS 0.091f ; **FLOATING
C2814 VIN.t345 VSS 0.02154f ; **FLOATING
C2815 VIN.t344 VSS 0.02154f ; **FLOATING
C2816 VIN.n1409 VSS 0.18683f ; **FLOATING
C2817 VIN.n1410 VSS 0.06549f ; **FLOATING
C2818 VIN.t217 VSS 0.02154f ; **FLOATING
C2819 VIN.t216 VSS 0.02154f ; **FLOATING
C2820 VIN.n1411 VSS 0.18683f ; **FLOATING
C2821 VIN.n1412 VSS 0.08805f ; **FLOATING
C2822 VIN.t215 VSS 0.02154f ; **FLOATING
C2823 VIN.t214 VSS 0.02154f ; **FLOATING
C2824 VIN.n1413 VSS 0.18683f ; **FLOATING
C2825 VIN.n1414 VSS 0.09062f ; **FLOATING
C2826 VIN.t280 VSS 0.02154f ; **FLOATING
C2827 VIN.t279 VSS 0.02154f ; **FLOATING
C2828 VIN.n1415 VSS 0.18683f ; **FLOATING
C2829 VIN.n1416 VSS 0.06292f ; **FLOATING
C2830 VIN.t278 VSS 0.02154f ; **FLOATING
C2831 VIN.t277 VSS 0.02154f ; **FLOATING
C2832 VIN.n1417 VSS 0.18683f ; **FLOATING
C2833 VIN.n1418 VSS 0.091f ; **FLOATING
C2834 VIN.t289 VSS 0.02154f ; **FLOATING
C2835 VIN.t288 VSS 0.02154f ; **FLOATING
C2836 VIN.n1419 VSS 0.18683f ; **FLOATING
C2837 VIN.n1420 VSS 0.08728f ; **FLOATING
C2838 VIN.t287 VSS 0.02154f ; **FLOATING
C2839 VIN.t286 VSS 0.02154f ; **FLOATING
C2840 VIN.n1421 VSS 0.18683f ; **FLOATING
C2841 VIN.n1422 VSS 0.06625f ; **FLOATING
C2842 VIN.t312 VSS 0.02154f ; **FLOATING
C2843 VIN.t311 VSS 0.02154f ; **FLOATING
C2844 VIN.n1423 VSS 0.18683f ; **FLOATING
C2845 VIN.n1424 VSS 0.091f ; **FLOATING
C2846 VIN.t310 VSS 0.02154f ; **FLOATING
C2847 VIN.t309 VSS 0.02154f ; **FLOATING
C2848 VIN.n1425 VSS 0.18683f ; **FLOATING
C2849 VIN.n1426 VSS 0.08395f ; **FLOATING
C2850 VIN.t11 VSS 0.02154f ; **FLOATING
C2851 VIN.t56 VSS 0.02154f ; **FLOATING
C2852 VIN.n1427 VSS 0.18683f ; **FLOATING
C2853 VIN.n1428 VSS 0.06959f ; **FLOATING
C2854 VIN.t123 VSS 0.02154f ; **FLOATING
C2855 VIN.t94 VSS 0.02154f ; **FLOATING
C2856 VIN.n1429 VSS 0.18683f ; **FLOATING
C2857 VIN.n1430 VSS 0.091f ; **FLOATING
C2858 VIN.t218 VSS 0.02154f ; **FLOATING
C2859 VIN.t1 VSS 0.02154f ; **FLOATING
C2860 VIN.n1431 VSS 0.18683f ; **FLOATING
C2861 VIN.n1432 VSS 0.08062f ; **FLOATING
C2862 VIN.t121 VSS 0.02154f ; **FLOATING
C2863 VIN.t9 VSS 0.02154f ; **FLOATING
C2864 VIN.n1433 VSS 0.18683f ; **FLOATING
C2865 VIN.n1434 VSS 0.07292f ; **FLOATING
C2866 VIN.t59 VSS 0.02154f ; **FLOATING
C2867 VIN.t54 VSS 0.02154f ; **FLOATING
C2868 VIN.n1435 VSS 0.18683f ; **FLOATING
C2869 VIN.n1436 VSS 0.17599f ; **FLOATING
C2870 VIN.t40 VSS 0.22003f ; **FLOATING
C2871 VIN.n1437 VSS 0.29968f ; **FLOATING
C2872 VIN.t304 VSS 0.02154f ; **FLOATING
C2873 VIN.t327 VSS 0.02154f ; **FLOATING
C2874 VIN.n1438 VSS 0.18683f ; **FLOATING
C2875 VIN.n1439 VSS 0.091f ; **FLOATING
C2876 VIN.t142 VSS 0.02154f ; **FLOATING
C2877 VIN.t7 VSS 0.02154f ; **FLOATING
C2878 VIN.n1440 VSS 0.18683f ; **FLOATING
C2879 VIN.n1441 VSS 0.08549f ; **FLOATING
C2880 VIN.t76 VSS 0.02154f ; **FLOATING
C2881 VIN.t92 VSS 0.02154f ; **FLOATING
C2882 VIN.n1442 VSS 0.18683f ; **FLOATING
C2883 VIN.n1443 VSS 0.06805f ; **FLOATING
C2884 VIN.t302 VSS 0.02154f ; **FLOATING
C2885 VIN.t266 VSS 0.02154f ; **FLOATING
C2886 VIN.n1444 VSS 0.18683f ; **FLOATING
C2887 VIN.n1445 VSS 0.091f ; **FLOATING
C2888 VIN.t330 VSS 0.02154f ; **FLOATING
C2889 VIN.t90 VSS 0.02154f ; **FLOATING
C2890 VIN.n1446 VSS 0.18683f ; **FLOATING
C2891 VIN.n1447 VSS 0.08215f ; **FLOATING
C2892 VIN.t313 VSS 0.02154f ; **FLOATING
C2893 VIN.t27 VSS 0.02154f ; **FLOATING
C2894 VIN.n1448 VSS 0.18683f ; **FLOATING
C2895 VIN.n1449 VSS 0.07138f ; **FLOATING
C2896 VIN.t270 VSS 0.02154f ; **FLOATING
C2897 VIN.t101 VSS 0.02154f ; **FLOATING
C2898 VIN.n1450 VSS 0.18683f ; **FLOATING
C2899 VIN.n1451 VSS 0.091f ; **FLOATING
C2900 VIN.t285 VSS 0.02154f ; **FLOATING
C2901 VIN.t267 VSS 0.02154f ; **FLOATING
C2902 VIN.n1452 VSS 0.18683f ; **FLOATING
C2903 VIN.n1453 VSS 0.07882f ; **FLOATING
C2904 VIN.t99 VSS 0.02154f ; **FLOATING
C2905 VIN.t268 VSS 0.02154f ; **FLOATING
C2906 VIN.n1454 VSS 0.18683f ; **FLOATING
C2907 VIN.n1455 VSS 0.07472f ; **FLOATING
C2908 VIN.t269 VSS 0.02154f ; **FLOATING
C2909 VIN.t18 VSS 0.02154f ; **FLOATING
C2910 VIN.n1456 VSS 0.18683f ; **FLOATING
C2911 VIN.n1457 VSS 0.091f ; **FLOATING
C2912 VIN.t115 VSS 0.02154f ; **FLOATING
C2913 VIN.t52 VSS 0.02154f ; **FLOATING
C2914 VIN.n1458 VSS 0.18683f ; **FLOATING
C2915 VIN.n1459 VSS 0.07549f ; **FLOATING
C2916 VIN.t339 VSS 0.02154f ; **FLOATING
C2917 VIN.t29 VSS 0.02154f ; **FLOATING
C2918 VIN.n1460 VSS 0.18683f ; **FLOATING
C2919 VIN.n1461 VSS 0.07805f ; **FLOATING
C2920 VIN.t106 VSS 0.02154f ; **FLOATING
C2921 VIN.t291 VSS 0.02154f ; **FLOATING
C2922 VIN.n1462 VSS 0.18683f ; **FLOATING
C2923 VIN.n1463 VSS 0.091f ; **FLOATING
C2924 VIN.t96 VSS 0.02154f ; **FLOATING
C2925 VIN.t297 VSS 0.02154f ; **FLOATING
C2926 VIN.n1464 VSS 0.18683f ; **FLOATING
C2927 VIN.n1465 VSS 0.07215f ; **FLOATING
C2928 VIN.t334 VSS 0.02154f ; **FLOATING
C2929 VIN.t331 VSS 0.02154f ; **FLOATING
C2930 VIN.n1466 VSS 0.18683f ; **FLOATING
C2931 VIN.n1467 VSS 0.08139f ; **FLOATING
C2932 VIN.t74 VSS 0.02154f ; **FLOATING
C2933 VIN.t139 VSS 0.02154f ; **FLOATING
C2934 VIN.n1468 VSS 0.18683f ; **FLOATING
C2935 VIN.n1469 VSS 0.091f ; **FLOATING
C2936 VIN.t141 VSS 0.02154f ; **FLOATING
C2937 VIN.t37 VSS 0.02154f ; **FLOATING
C2938 VIN.n1470 VSS 0.18683f ; **FLOATING
C2939 VIN.n1471 VSS 0.06882f ; **FLOATING
C2940 VIN.t33 VSS 0.02154f ; **FLOATING
C2941 VIN.t46 VSS 0.02154f ; **FLOATING
C2942 VIN.n1472 VSS 0.18683f ; **FLOATING
C2943 VIN.n1473 VSS 0.08472f ; **FLOATING
C2944 VIN.t303 VSS 0.02154f ; **FLOATING
C2945 VIN.t64 VSS 0.02154f ; **FLOATING
C2946 VIN.n1474 VSS 0.18683f ; **FLOATING
C2947 VIN.n1475 VSS 0.091f ; **FLOATING
C2948 VIN.t78 VSS 0.02154f ; **FLOATING
C2949 VIN.t103 VSS 0.02154f ; **FLOATING
C2950 VIN.n1476 VSS 0.18683f ; **FLOATING
C2951 VIN.n1477 VSS 0.06549f ; **FLOATING
C2952 VIN.t296 VSS 0.02154f ; **FLOATING
C2953 VIN.t119 VSS 0.02154f ; **FLOATING
C2954 VIN.n1478 VSS 0.18683f ; **FLOATING
C2955 VIN.n1479 VSS 0.08805f ; **FLOATING
C2956 VIN.t31 VSS 0.02154f ; **FLOATING
C2957 VIN.t13 VSS 0.02154f ; **FLOATING
C2958 VIN.n1480 VSS 0.18683f ; **FLOATING
C2959 VIN.n1481 VSS 0.09062f ; **FLOATING
C2960 VIN.t332 VSS 0.02154f ; **FLOATING
C2961 VIN.t295 VSS 0.02154f ; **FLOATING
C2962 VIN.n1482 VSS 0.18683f ; **FLOATING
C2963 VIN.n1483 VSS 0.06292f ; **FLOATING
C2964 VIN.t271 VSS 0.02154f ; **FLOATING
C2965 VIN.t49 VSS 0.02154f ; **FLOATING
C2966 VIN.n1484 VSS 0.18683f ; **FLOATING
C2967 VIN.n1485 VSS 0.091f ; **FLOATING
C2968 VIN.t3 VSS 0.02154f ; **FLOATING
C2969 VIN.t276 VSS 0.02154f ; **FLOATING
C2970 VIN.n1486 VSS 0.18683f ; **FLOATING
C2971 VIN.n1487 VSS 0.08728f ; **FLOATING
C2972 VIN.t208 VSS 0.02154f ; **FLOATING
C2973 VIN.t16 VSS 0.02154f ; **FLOATING
C2974 VIN.n1488 VSS 0.18683f ; **FLOATING
C2975 VIN.n1489 VSS 0.06625f ; **FLOATING
C2976 VIN.t25 VSS 0.02154f ; **FLOATING
C2977 VIN.t62 VSS 0.02154f ; **FLOATING
C2978 VIN.n1490 VSS 0.18683f ; **FLOATING
C2979 VIN.n1491 VSS 0.091f ; **FLOATING
C2980 VIN.t5 VSS 0.02154f ; **FLOATING
C2981 VIN.t42 VSS 0.02154f ; **FLOATING
C2982 VIN.n1492 VSS 0.18683f ; **FLOATING
C2983 VIN.n1493 VSS 0.08395f ; **FLOATING
C2984 VIN.t55 VSS 0.02154f ; **FLOATING
C2985 VIN.t44 VSS 0.02154f ; **FLOATING
C2986 VIN.n1494 VSS 0.18683f ; **FLOATING
C2987 VIN.n1495 VSS 0.06959f ; **FLOATING
C2988 VIN.t213 VSS 0.02154f ; **FLOATING
C2989 VIN.t294 VSS 0.02154f ; **FLOATING
C2990 VIN.n1496 VSS 0.18683f ; **FLOATING
C2991 VIN.n1497 VSS 0.091f ; **FLOATING
C2992 VIN.t21 VSS 0.02154f ; **FLOATING
C2993 VIN.t57 VSS 0.02154f ; **FLOATING
C2994 VIN.n1498 VSS 0.18683f ; **FLOATING
C2995 VIN.n1499 VSS 0.08062f ; **FLOATING
C2996 VIN.t292 VSS 0.02154f ; **FLOATING
C2997 VIN.t47 VSS 0.02154f ; **FLOATING
C2998 VIN.n1500 VSS 0.18683f ; **FLOATING
C2999 VIN.n1501 VSS 0.07292f ; **FLOATING
C3000 VIN.t257 VSS 0.02154f ; **FLOATING
C3001 VIN.t255 VSS 0.02154f ; **FLOATING
C3002 VIN.n1502 VSS 0.18683f ; **FLOATING
C3003 VIN.n1503 VSS 0.17599f ; **FLOATING
C3004 VIN.t293 VSS 0.22003f ; **FLOATING
C3005 VIN.n1504 VSS 0.0618f ; **FLOATING
C3006 VIN.n1505 VSS 1.20231f ; **FLOATING
C3007 VOUT.n0 VSS 3.3423f ; **FLOATING
C3008 VOUT.t12 VSS 2.76337f ; **FLOATING
C3009 VOUT.n1 VSS 19.7282f ; **FLOATING
C3010 VOUT.n2 VSS 5.84566f ; **FLOATING
C3011 VOUT.n3 VSS 5.84566f ; **FLOATING
C3012 VOUT.n4 VSS 5.84566f ; **FLOATING
C3013 VOUT.n5 VSS 5.84566f ; **FLOATING
C3014 VOUT.n6 VSS 5.84566f ; **FLOATING
C3015 VOUT.n7 VSS 5.84566f ; **FLOATING
C3016 VOUT.n8 VSS 5.84566f ; **FLOATING
C3017 VOUT.n9 VSS 5.84566f ; **FLOATING
C3018 VOUT.n10 VSS 5.84566f ; **FLOATING
C3019 VOUT.n11 VSS 2.42478f ; **FLOATING
C3020 VOUT.n12 VSS 3.01657f ; **FLOATING
C3021 VOUT.t66 VSS 0.05048f ; **FLOATING
C3022 VOUT.t135 VSS 0.05048f ; **FLOATING
C3023 VOUT.n13 VSS 0.4725f ; **FLOATING
C3024 VOUT.n14 VSS 0.38451f ; **FLOATING
C3025 VOUT.t68 VSS 0.05048f ; **FLOATING
C3026 VOUT.t174 VSS 0.05048f ; **FLOATING
C3027 VOUT.n15 VSS 0.4725f ; **FLOATING
C3028 VOUT.n16 VSS 0.21383f ; **FLOATING
C3029 VOUT.t196 VSS 0.05048f ; **FLOATING
C3030 VOUT.t70 VSS 0.05048f ; **FLOATING
C3031 VOUT.n17 VSS 0.4725f ; **FLOATING
C3032 VOUT.n18 VSS 0.16515f ; **FLOATING
C3033 VOUT.n19 VSS 0.26435f ; **FLOATING
C3034 VOUT.n20 VSS 0.26435f ; **FLOATING
C3035 VOUT.n21 VSS 0.26435f ; **FLOATING
C3036 VOUT.n22 VSS 0.26435f ; **FLOATING
C3037 VOUT.n23 VSS 0.26435f ; **FLOATING
C3038 VOUT.n24 VSS 0.26435f ; **FLOATING
C3039 VOUT.n25 VSS 0.26435f ; **FLOATING
C3040 VOUT.n26 VSS 0.26435f ; **FLOATING
C3041 VOUT.n27 VSS 0.26435f ; **FLOATING
C3042 VOUT.n28 VSS 0.26435f ; **FLOATING
C3043 VOUT.n29 VSS 0.26435f ; **FLOATING
C3044 VOUT.t60 VSS 0.05048f ; **FLOATING
C3045 VOUT.t59 VSS 0.05048f ; **FLOATING
C3046 VOUT.n30 VSS 0.4725f ; **FLOATING
C3047 VOUT.n31 VSS 0.34606f ; **FLOATING
C3048 VOUT.t58 VSS 0.05048f ; **FLOATING
C3049 VOUT.t41 VSS 0.05048f ; **FLOATING
C3050 VOUT.n32 VSS 0.4725f ; **FLOATING
C3051 VOUT.n33 VSS 0.21383f ; **FLOATING
C3052 VOUT.t40 VSS 0.05048f ; **FLOATING
C3053 VOUT.t39 VSS 0.05048f ; **FLOATING
C3054 VOUT.n34 VSS 0.4725f ; **FLOATING
C3055 VOUT.n35 VSS 0.16515f ; **FLOATING
C3056 VOUT.n36 VSS 0.14484f ; **FLOATING
C3057 VOUT.n37 VSS 0.14484f ; **FLOATING
C3058 VOUT.n38 VSS 0.14484f ; **FLOATING
C3059 VOUT.n39 VSS 0.14484f ; **FLOATING
C3060 VOUT.n40 VSS 0.14484f ; **FLOATING
C3061 VOUT.n41 VSS 0.14484f ; **FLOATING
C3062 VOUT.n42 VSS 0.14484f ; **FLOATING
C3063 VOUT.n43 VSS 0.14484f ; **FLOATING
C3064 VOUT.n44 VSS 0.14484f ; **FLOATING
C3065 VOUT.n45 VSS 0.14484f ; **FLOATING
C3066 VOUT.n46 VSS 0.14484f ; **FLOATING
C3067 VOUT.t71 VSS 0.05048f ; **FLOATING
C3068 VOUT.t75 VSS 0.05048f ; **FLOATING
C3069 VOUT.n47 VSS 0.4725f ; **FLOATING
C3070 VOUT.n48 VSS 0.38451f ; **FLOATING
C3071 VOUT.t74 VSS 0.05048f ; **FLOATING
C3072 VOUT.t73 VSS 0.05048f ; **FLOATING
C3073 VOUT.n49 VSS 0.4725f ; **FLOATING
C3074 VOUT.n50 VSS 0.21383f ; **FLOATING
C3075 VOUT.t72 VSS 0.05048f ; **FLOATING
C3076 VOUT.t124 VSS 0.05048f ; **FLOATING
C3077 VOUT.n51 VSS 0.4725f ; **FLOATING
C3078 VOUT.n52 VSS 0.16515f ; **FLOATING
C3079 VOUT.n53 VSS 0.14484f ; **FLOATING
C3080 VOUT.n54 VSS 3.01657f ; **FLOATING
C3081 VOUT.n55 VSS 4.64313f ; **FLOATING
C3082 VOUT.n56 VSS 0.14484f ; **FLOATING
C3083 VOUT.n57 VSS 3.01657f ; **FLOATING
C3084 VOUT.n58 VSS 2.42478f ; **FLOATING
C3085 VOUT.n59 VSS 0.14484f ; **FLOATING
C3086 VOUT.n60 VSS 3.01657f ; **FLOATING
C3087 VOUT.n61 VSS 2.42478f ; **FLOATING
C3088 VOUT.n62 VSS 0.14484f ; **FLOATING
C3089 VOUT.n63 VSS 3.01657f ; **FLOATING
C3090 VOUT.n64 VSS 2.42478f ; **FLOATING
C3091 VOUT.n65 VSS 0.14484f ; **FLOATING
C3092 VOUT.n66 VSS 3.01657f ; **FLOATING
C3093 VOUT.n67 VSS 2.42478f ; **FLOATING
C3094 VOUT.n68 VSS 0.14484f ; **FLOATING
C3095 VOUT.n69 VSS 3.01657f ; **FLOATING
C3096 VOUT.n70 VSS 2.42478f ; **FLOATING
C3097 VOUT.n71 VSS 0.14484f ; **FLOATING
C3098 VOUT.n72 VSS 3.01657f ; **FLOATING
C3099 VOUT.n73 VSS 2.42478f ; **FLOATING
C3100 VOUT.n74 VSS 0.14484f ; **FLOATING
C3101 VOUT.n75 VSS 3.01657f ; **FLOATING
C3102 VOUT.n76 VSS 2.42478f ; **FLOATING
C3103 VOUT.n77 VSS 0.14484f ; **FLOATING
C3104 VOUT.n78 VSS 3.01657f ; **FLOATING
C3105 VOUT.n79 VSS 2.42478f ; **FLOATING
C3106 VOUT.n80 VSS 0.14484f ; **FLOATING
C3107 VOUT.n81 VSS 3.01657f ; **FLOATING
C3108 VOUT.n82 VSS 2.42478f ; **FLOATING
C3109 VOUT.n83 VSS 0.33888f ; **FLOATING
C3110 VOUT.t123 VSS 0.05048f ; **FLOATING
C3111 VOUT.t122 VSS 0.05048f ; **FLOATING
C3112 VOUT.n84 VSS 0.4725f ; **FLOATING
C3113 VOUT.n85 VSS 0.22284f ; **FLOATING
C3114 VOUT.t121 VSS 0.05048f ; **FLOATING
C3115 VOUT.t79 VSS 0.05048f ; **FLOATING
C3116 VOUT.n86 VSS 0.4725f ; **FLOATING
C3117 VOUT.n87 VSS 0.20601f ; **FLOATING
C3118 VOUT.t78 VSS 0.05048f ; **FLOATING
C3119 VOUT.t77 VSS 0.05048f ; **FLOATING
C3120 VOUT.n88 VSS 0.4725f ; **FLOATING
C3121 VOUT.n89 VSS 0.17296f ; **FLOATING
C3122 VOUT.t76 VSS 0.05048f ; **FLOATING
C3123 VOUT.t83 VSS 0.05048f ; **FLOATING
C3124 VOUT.n90 VSS 0.4725f ; **FLOATING
C3125 VOUT.n91 VSS 0.22284f ; **FLOATING
C3126 VOUT.t82 VSS 0.05048f ; **FLOATING
C3127 VOUT.t81 VSS 0.05048f ; **FLOATING
C3128 VOUT.n92 VSS 0.4725f ; **FLOATING
C3129 VOUT.n93 VSS 0.1982f ; **FLOATING
C3130 VOUT.t80 VSS 0.05048f ; **FLOATING
C3131 VOUT.t87 VSS 0.05048f ; **FLOATING
C3132 VOUT.n94 VSS 0.4725f ; **FLOATING
C3133 VOUT.n95 VSS 0.18077f ; **FLOATING
C3134 VOUT.t86 VSS 0.05048f ; **FLOATING
C3135 VOUT.t85 VSS 0.05048f ; **FLOATING
C3136 VOUT.n96 VSS 0.4725f ; **FLOATING
C3137 VOUT.n97 VSS 0.22284f ; **FLOATING
C3138 VOUT.t84 VSS 0.05048f ; **FLOATING
C3139 VOUT.t91 VSS 0.05048f ; **FLOATING
C3140 VOUT.n98 VSS 0.4725f ; **FLOATING
C3141 VOUT.n99 VSS 0.19039f ; **FLOATING
C3142 VOUT.t90 VSS 0.05048f ; **FLOATING
C3143 VOUT.t89 VSS 0.05048f ; **FLOATING
C3144 VOUT.n100 VSS 0.4725f ; **FLOATING
C3145 VOUT.n101 VSS 0.18858f ; **FLOATING
C3146 VOUT.t88 VSS 0.05048f ; **FLOATING
C3147 VOUT.t204 VSS 0.05048f ; **FLOATING
C3148 VOUT.n102 VSS 0.4725f ; **FLOATING
C3149 VOUT.n103 VSS 0.22284f ; **FLOATING
C3150 VOUT.t203 VSS 0.05048f ; **FLOATING
C3151 VOUT.t202 VSS 0.05048f ; **FLOATING
C3152 VOUT.n104 VSS 0.4725f ; **FLOATING
C3153 VOUT.n105 VSS 0.18257f ; **FLOATING
C3154 VOUT.t201 VSS 0.05048f ; **FLOATING
C3155 VOUT.t95 VSS 0.05048f ; **FLOATING
C3156 VOUT.n106 VSS 0.4725f ; **FLOATING
C3157 VOUT.n107 VSS 0.1964f ; **FLOATING
C3158 VOUT.t94 VSS 0.05048f ; **FLOATING
C3159 VOUT.t93 VSS 0.05048f ; **FLOATING
C3160 VOUT.n108 VSS 0.4725f ; **FLOATING
C3161 VOUT.n109 VSS 0.22284f ; **FLOATING
C3162 VOUT.t92 VSS 0.05048f ; **FLOATING
C3163 VOUT.t99 VSS 0.05048f ; **FLOATING
C3164 VOUT.n110 VSS 0.4725f ; **FLOATING
C3165 VOUT.n111 VSS 0.17476f ; **FLOATING
C3166 VOUT.t98 VSS 0.05048f ; **FLOATING
C3167 VOUT.t97 VSS 0.05048f ; **FLOATING
C3168 VOUT.n112 VSS 0.4725f ; **FLOATING
C3169 VOUT.n113 VSS 0.20421f ; **FLOATING
C3170 VOUT.t96 VSS 0.05048f ; **FLOATING
C3171 VOUT.t103 VSS 0.05048f ; **FLOATING
C3172 VOUT.n114 VSS 0.4725f ; **FLOATING
C3173 VOUT.n115 VSS 0.22284f ; **FLOATING
C3174 VOUT.t102 VSS 0.05048f ; **FLOATING
C3175 VOUT.t101 VSS 0.05048f ; **FLOATING
C3176 VOUT.n116 VSS 0.4725f ; **FLOATING
C3177 VOUT.n117 VSS 0.16695f ; **FLOATING
C3178 VOUT.t100 VSS 0.05048f ; **FLOATING
C3179 VOUT.t65 VSS 0.05048f ; **FLOATING
C3180 VOUT.n118 VSS 0.4725f ; **FLOATING
C3181 VOUT.n119 VSS 0.21202f ; **FLOATING
C3182 VOUT.t64 VSS 0.05048f ; **FLOATING
C3183 VOUT.t63 VSS 0.05048f ; **FLOATING
C3184 VOUT.n120 VSS 0.4725f ; **FLOATING
C3185 VOUT.n121 VSS 0.22284f ; **FLOATING
C3186 VOUT.t62 VSS 0.05048f ; **FLOATING
C3187 VOUT.t107 VSS 0.05048f ; **FLOATING
C3188 VOUT.n122 VSS 0.4725f ; **FLOATING
C3189 VOUT.n123 VSS 0.15913f ; **FLOATING
C3190 VOUT.t106 VSS 0.05048f ; **FLOATING
C3191 VOUT.t105 VSS 0.05048f ; **FLOATING
C3192 VOUT.n124 VSS 0.4725f ; **FLOATING
C3193 VOUT.n125 VSS 0.21983f ; **FLOATING
C3194 VOUT.t104 VSS 0.05048f ; **FLOATING
C3195 VOUT.t111 VSS 0.05048f ; **FLOATING
C3196 VOUT.n126 VSS 0.4725f ; **FLOATING
C3197 VOUT.n127 VSS 0.21803f ; **FLOATING
C3198 VOUT.t110 VSS 0.05048f ; **FLOATING
C3199 VOUT.t109 VSS 0.05048f ; **FLOATING
C3200 VOUT.n128 VSS 0.4725f ; **FLOATING
C3201 VOUT.n129 VSS 0.16094f ; **FLOATING
C3202 VOUT.t108 VSS 0.05048f ; **FLOATING
C3203 VOUT.t115 VSS 0.05048f ; **FLOATING
C3204 VOUT.n130 VSS 0.4725f ; **FLOATING
C3205 VOUT.n131 VSS 0.22284f ; **FLOATING
C3206 VOUT.t114 VSS 0.05048f ; **FLOATING
C3207 VOUT.t113 VSS 0.05048f ; **FLOATING
C3208 VOUT.n132 VSS 0.4725f ; **FLOATING
C3209 VOUT.n133 VSS 0.21022f ; **FLOATING
C3210 VOUT.t112 VSS 0.05048f ; **FLOATING
C3211 VOUT.t119 VSS 0.05048f ; **FLOATING
C3212 VOUT.n134 VSS 0.4725f ; **FLOATING
C3213 VOUT.n135 VSS 0.16875f ; **FLOATING
C3214 VOUT.t118 VSS 0.05048f ; **FLOATING
C3215 VOUT.t117 VSS 0.05048f ; **FLOATING
C3216 VOUT.n136 VSS 0.4725f ; **FLOATING
C3217 VOUT.n137 VSS 0.22284f ; **FLOATING
C3218 VOUT.t116 VSS 0.05048f ; **FLOATING
C3219 VOUT.t171 VSS 0.05048f ; **FLOATING
C3220 VOUT.n138 VSS 0.4725f ; **FLOATING
C3221 VOUT.n139 VSS 0.20241f ; **FLOATING
C3222 VOUT.t170 VSS 0.05048f ; **FLOATING
C3223 VOUT.t169 VSS 0.05048f ; **FLOATING
C3224 VOUT.n140 VSS 0.4725f ; **FLOATING
C3225 VOUT.n141 VSS 0.17656f ; **FLOATING
C3226 VOUT.t168 VSS 0.05048f ; **FLOATING
C3227 VOUT.t178 VSS 0.05048f ; **FLOATING
C3228 VOUT.n142 VSS 0.4725f ; **FLOATING
C3229 VOUT.n143 VSS 0.22284f ; **FLOATING
C3230 VOUT.t177 VSS 0.05048f ; **FLOATING
C3231 VOUT.t176 VSS 0.05048f ; **FLOATING
C3232 VOUT.n144 VSS 0.4725f ; **FLOATING
C3233 VOUT.n145 VSS 0.19459f ; **FLOATING
C3234 VOUT.t175 VSS 0.05048f ; **FLOATING
C3235 VOUT.t61 VSS 0.05048f ; **FLOATING
C3236 VOUT.n146 VSS 0.47786f ; **FLOATING
C3237 VOUT.n147 VSS 0.14484f ; **FLOATING
C3238 VOUT.n148 VSS 2.42478f ; **FLOATING
C3239 VOUT.n149 VSS 3.01657f ; **FLOATING
C3240 VOUT.n150 VSS 0.33888f ; **FLOATING
C3241 VOUT.t38 VSS 0.05048f ; **FLOATING
C3242 VOUT.t53 VSS 0.05048f ; **FLOATING
C3243 VOUT.n151 VSS 0.4725f ; **FLOATING
C3244 VOUT.n152 VSS 0.22284f ; **FLOATING
C3245 VOUT.t52 VSS 0.05048f ; **FLOATING
C3246 VOUT.t51 VSS 0.05048f ; **FLOATING
C3247 VOUT.n153 VSS 0.4725f ; **FLOATING
C3248 VOUT.n154 VSS 0.20601f ; **FLOATING
C3249 VOUT.t50 VSS 0.05048f ; **FLOATING
C3250 VOUT.t146 VSS 0.05048f ; **FLOATING
C3251 VOUT.n155 VSS 0.4725f ; **FLOATING
C3252 VOUT.n156 VSS 0.17296f ; **FLOATING
C3253 VOUT.t145 VSS 0.05048f ; **FLOATING
C3254 VOUT.t144 VSS 0.05048f ; **FLOATING
C3255 VOUT.n157 VSS 0.4725f ; **FLOATING
C3256 VOUT.n158 VSS 0.22284f ; **FLOATING
C3257 VOUT.t143 VSS 0.05048f ; **FLOATING
C3258 VOUT.t195 VSS 0.05048f ; **FLOATING
C3259 VOUT.n159 VSS 0.4725f ; **FLOATING
C3260 VOUT.n160 VSS 0.1982f ; **FLOATING
C3261 VOUT.t194 VSS 0.05048f ; **FLOATING
C3262 VOUT.t193 VSS 0.05048f ; **FLOATING
C3263 VOUT.n161 VSS 0.4725f ; **FLOATING
C3264 VOUT.n162 VSS 0.18077f ; **FLOATING
C3265 VOUT.t192 VSS 0.05048f ; **FLOATING
C3266 VOUT.t209 VSS 0.05048f ; **FLOATING
C3267 VOUT.n163 VSS 0.4725f ; **FLOATING
C3268 VOUT.n164 VSS 0.22284f ; **FLOATING
C3269 VOUT.t208 VSS 0.05048f ; **FLOATING
C3270 VOUT.t207 VSS 0.05048f ; **FLOATING
C3271 VOUT.n165 VSS 0.4725f ; **FLOATING
C3272 VOUT.n166 VSS 0.19039f ; **FLOATING
C3273 VOUT.t206 VSS 0.05048f ; **FLOATING
C3274 VOUT.t191 VSS 0.05048f ; **FLOATING
C3275 VOUT.n167 VSS 0.4725f ; **FLOATING
C3276 VOUT.n168 VSS 0.18858f ; **FLOATING
C3277 VOUT.t190 VSS 0.05048f ; **FLOATING
C3278 VOUT.t189 VSS 0.05048f ; **FLOATING
C3279 VOUT.n169 VSS 0.4725f ; **FLOATING
C3280 VOUT.n170 VSS 0.22284f ; **FLOATING
C3281 VOUT.t188 VSS 0.05048f ; **FLOATING
C3282 VOUT.t187 VSS 0.05048f ; **FLOATING
C3283 VOUT.n171 VSS 0.4725f ; **FLOATING
C3284 VOUT.n172 VSS 0.18257f ; **FLOATING
C3285 VOUT.t186 VSS 0.05048f ; **FLOATING
C3286 VOUT.t185 VSS 0.05048f ; **FLOATING
C3287 VOUT.n173 VSS 0.4725f ; **FLOATING
C3288 VOUT.n174 VSS 0.1964f ; **FLOATING
C3289 VOUT.t184 VSS 0.05048f ; **FLOATING
C3290 VOUT.t155 VSS 0.05048f ; **FLOATING
C3291 VOUT.n175 VSS 0.4725f ; **FLOATING
C3292 VOUT.n176 VSS 0.22284f ; **FLOATING
C3293 VOUT.t154 VSS 0.05048f ; **FLOATING
C3294 VOUT.t153 VSS 0.05048f ; **FLOATING
C3295 VOUT.n177 VSS 0.4725f ; **FLOATING
C3296 VOUT.n178 VSS 0.17476f ; **FLOATING
C3297 VOUT.t152 VSS 0.05048f ; **FLOATING
C3298 VOUT.t34 VSS 0.05048f ; **FLOATING
C3299 VOUT.n179 VSS 0.4725f ; **FLOATING
C3300 VOUT.n180 VSS 0.20421f ; **FLOATING
C3301 VOUT.t33 VSS 0.05048f ; **FLOATING
C3302 VOUT.t32 VSS 0.05048f ; **FLOATING
C3303 VOUT.n181 VSS 0.4725f ; **FLOATING
C3304 VOUT.n182 VSS 0.22284f ; **FLOATING
C3305 VOUT.t31 VSS 0.05048f ; **FLOATING
C3306 VOUT.t213 VSS 0.05048f ; **FLOATING
C3307 VOUT.n183 VSS 0.4725f ; **FLOATING
C3308 VOUT.n184 VSS 0.16695f ; **FLOATING
C3309 VOUT.t212 VSS 0.05048f ; **FLOATING
C3310 VOUT.t211 VSS 0.05048f ; **FLOATING
C3311 VOUT.n185 VSS 0.4725f ; **FLOATING
C3312 VOUT.n186 VSS 0.21202f ; **FLOATING
C3313 VOUT.t210 VSS 0.05048f ; **FLOATING
C3314 VOUT.t129 VSS 0.05048f ; **FLOATING
C3315 VOUT.n187 VSS 0.4725f ; **FLOATING
C3316 VOUT.n188 VSS 0.22284f ; **FLOATING
C3317 VOUT.t128 VSS 0.05048f ; **FLOATING
C3318 VOUT.t127 VSS 0.05048f ; **FLOATING
C3319 VOUT.n189 VSS 0.4725f ; **FLOATING
C3320 VOUT.n190 VSS 0.15913f ; **FLOATING
C3321 VOUT.t126 VSS 0.05048f ; **FLOATING
C3322 VOUT.t151 VSS 0.05048f ; **FLOATING
C3323 VOUT.n191 VSS 0.4725f ; **FLOATING
C3324 VOUT.n192 VSS 0.21983f ; **FLOATING
C3325 VOUT.t150 VSS 0.05048f ; **FLOATING
C3326 VOUT.t149 VSS 0.05048f ; **FLOATING
C3327 VOUT.n193 VSS 0.4725f ; **FLOATING
C3328 VOUT.n194 VSS 0.21803f ; **FLOATING
C3329 VOUT.t148 VSS 0.05048f ; **FLOATING
C3330 VOUT.t160 VSS 0.05048f ; **FLOATING
C3331 VOUT.n195 VSS 0.4725f ; **FLOATING
C3332 VOUT.n196 VSS 0.16094f ; **FLOATING
C3333 VOUT.t159 VSS 0.05048f ; **FLOATING
C3334 VOUT.t158 VSS 0.05048f ; **FLOATING
C3335 VOUT.n197 VSS 0.4725f ; **FLOATING
C3336 VOUT.n198 VSS 0.22284f ; **FLOATING
C3337 VOUT.t157 VSS 0.05048f ; **FLOATING
C3338 VOUT.t182 VSS 0.05048f ; **FLOATING
C3339 VOUT.n199 VSS 0.4725f ; **FLOATING
C3340 VOUT.n200 VSS 0.21022f ; **FLOATING
C3341 VOUT.t181 VSS 0.05048f ; **FLOATING
C3342 VOUT.t180 VSS 0.05048f ; **FLOATING
C3343 VOUT.n201 VSS 0.4725f ; **FLOATING
C3344 VOUT.n202 VSS 0.16875f ; **FLOATING
C3345 VOUT.t179 VSS 0.05048f ; **FLOATING
C3346 VOUT.t5 VSS 0.05048f ; **FLOATING
C3347 VOUT.n203 VSS 0.4725f ; **FLOATING
C3348 VOUT.n204 VSS 0.22284f ; **FLOATING
C3349 VOUT.t26 VSS 0.05048f ; **FLOATING
C3350 VOUT.t57 VSS 0.05048f ; **FLOATING
C3351 VOUT.n205 VSS 0.4725f ; **FLOATING
C3352 VOUT.n206 VSS 0.20241f ; **FLOATING
C3353 VOUT.t44 VSS 0.05048f ; **FLOATING
C3354 VOUT.t130 VSS 0.05048f ; **FLOATING
C3355 VOUT.n207 VSS 0.4725f ; **FLOATING
C3356 VOUT.n208 VSS 0.17656f ; **FLOATING
C3357 VOUT.t0 VSS 0.05048f ; **FLOATING
C3358 VOUT.t56 VSS 0.05048f ; **FLOATING
C3359 VOUT.n209 VSS 0.4725f ; **FLOATING
C3360 VOUT.n210 VSS 0.22284f ; **FLOATING
C3361 VOUT.t4 VSS 0.05048f ; **FLOATING
C3362 VOUT.t28 VSS 0.05048f ; **FLOATING
C3363 VOUT.n211 VSS 0.4725f ; **FLOATING
C3364 VOUT.n212 VSS 0.19459f ; **FLOATING
C3365 VOUT.t24 VSS 0.05048f ; **FLOATING
C3366 VOUT.t17 VSS 0.05048f ; **FLOATING
C3367 VOUT.n213 VSS 0.47786f ; **FLOATING
C3368 VOUT.n214 VSS 0.73319f ; **FLOATING
C3369 VOUT.t3 VSS 0.05048f ; **FLOATING
C3370 VOUT.t36 VSS 0.05048f ; **FLOATING
C3371 VOUT.n215 VSS 0.4725f ; **FLOATING
C3372 VOUT.n216 VSS 0.22284f ; **FLOATING
C3373 VOUT.t43 VSS 0.05048f ; **FLOATING
C3374 VOUT.t172 VSS 0.05048f ; **FLOATING
C3375 VOUT.n217 VSS 0.4725f ; **FLOATING
C3376 VOUT.n218 VSS 0.20601f ; **FLOATING
C3377 VOUT.t137 VSS 0.05048f ; **FLOATING
C3378 VOUT.t197 VSS 0.05048f ; **FLOATING
C3379 VOUT.n219 VSS 0.4725f ; **FLOATING
C3380 VOUT.n220 VSS 0.17296f ; **FLOATING
C3381 VOUT.t42 VSS 0.05048f ; **FLOATING
C3382 VOUT.t183 VSS 0.05048f ; **FLOATING
C3383 VOUT.n221 VSS 0.4725f ; **FLOATING
C3384 VOUT.n222 VSS 0.22284f ; **FLOATING
C3385 VOUT.t11 VSS 0.05048f ; **FLOATING
C3386 VOUT.t141 VSS 0.05048f ; **FLOATING
C3387 VOUT.n223 VSS 0.4725f ; **FLOATING
C3388 VOUT.n224 VSS 0.1982f ; **FLOATING
C3389 VOUT.t47 VSS 0.05048f ; **FLOATING
C3390 VOUT.t156 VSS 0.05048f ; **FLOATING
C3391 VOUT.n225 VSS 0.4725f ; **FLOATING
C3392 VOUT.n226 VSS 0.18077f ; **FLOATING
C3393 VOUT.t138 VSS 0.05048f ; **FLOATING
C3394 VOUT.t46 VSS 0.05048f ; **FLOATING
C3395 VOUT.n227 VSS 0.4725f ; **FLOATING
C3396 VOUT.n228 VSS 0.22284f ; **FLOATING
C3397 VOUT.t139 VSS 0.05048f ; **FLOATING
C3398 VOUT.t140 VSS 0.05048f ; **FLOATING
C3399 VOUT.n229 VSS 0.4725f ; **FLOATING
C3400 VOUT.n230 VSS 0.19039f ; **FLOATING
C3401 VOUT.t8 VSS 0.05048f ; **FLOATING
C3402 VOUT.t54 VSS 0.05048f ; **FLOATING
C3403 VOUT.n231 VSS 0.4725f ; **FLOATING
C3404 VOUT.n232 VSS 0.18858f ; **FLOATING
C3405 VOUT.t23 VSS 0.05048f ; **FLOATING
C3406 VOUT.t205 VSS 0.05048f ; **FLOATING
C3407 VOUT.n233 VSS 0.4725f ; **FLOATING
C3408 VOUT.n234 VSS 0.22284f ; **FLOATING
C3409 VOUT.t13 VSS 0.05048f ; **FLOATING
C3410 VOUT.t49 VSS 0.05048f ; **FLOATING
C3411 VOUT.n235 VSS 0.4725f ; **FLOATING
C3412 VOUT.n236 VSS 0.18257f ; **FLOATING
C3413 VOUT.t161 VSS 0.05048f ; **FLOATING
C3414 VOUT.t45 VSS 0.05048f ; **FLOATING
C3415 VOUT.n237 VSS 0.4725f ; **FLOATING
C3416 VOUT.n238 VSS 0.1964f ; **FLOATING
C3417 VOUT.t167 VSS 0.05048f ; **FLOATING
C3418 VOUT.t200 VSS 0.05048f ; **FLOATING
C3419 VOUT.n239 VSS 0.4725f ; **FLOATING
C3420 VOUT.n240 VSS 0.22284f ; **FLOATING
C3421 VOUT.t198 VSS 0.05048f ; **FLOATING
C3422 VOUT.t35 VSS 0.05048f ; **FLOATING
C3423 VOUT.n241 VSS 0.4725f ; **FLOATING
C3424 VOUT.n242 VSS 0.17476f ; **FLOATING
C3425 VOUT.t67 VSS 0.05048f ; **FLOATING
C3426 VOUT.t69 VSS 0.05048f ; **FLOATING
C3427 VOUT.n243 VSS 0.4725f ; **FLOATING
C3428 VOUT.n244 VSS 0.20421f ; **FLOATING
C3429 VOUT.t16 VSS 0.05048f ; **FLOATING
C3430 VOUT.t15 VSS 0.05048f ; **FLOATING
C3431 VOUT.n245 VSS 0.4725f ; **FLOATING
C3432 VOUT.n246 VSS 0.22284f ; **FLOATING
C3433 VOUT.t20 VSS 0.05048f ; **FLOATING
C3434 VOUT.t173 VSS 0.05048f ; **FLOATING
C3435 VOUT.n247 VSS 0.4725f ; **FLOATING
C3436 VOUT.n248 VSS 0.16695f ; **FLOATING
C3437 VOUT.t30 VSS 0.05048f ; **FLOATING
C3438 VOUT.t37 VSS 0.05048f ; **FLOATING
C3439 VOUT.n249 VSS 0.4725f ; **FLOATING
C3440 VOUT.n250 VSS 0.21202f ; **FLOATING
C3441 VOUT.t48 VSS 0.05048f ; **FLOATING
C3442 VOUT.t166 VSS 0.05048f ; **FLOATING
C3443 VOUT.n251 VSS 0.4725f ; **FLOATING
C3444 VOUT.n252 VSS 0.22284f ; **FLOATING
C3445 VOUT.t55 VSS 0.05048f ; **FLOATING
C3446 VOUT.t14 VSS 0.05048f ; **FLOATING
C3447 VOUT.n253 VSS 0.4725f ; **FLOATING
C3448 VOUT.n254 VSS 0.15913f ; **FLOATING
C3449 VOUT.t6 VSS 0.05048f ; **FLOATING
C3450 VOUT.t199 VSS 0.05048f ; **FLOATING
C3451 VOUT.n255 VSS 0.4725f ; **FLOATING
C3452 VOUT.n256 VSS 0.21983f ; **FLOATING
C3453 VOUT.t165 VSS 0.05048f ; **FLOATING
C3454 VOUT.t142 VSS 0.05048f ; **FLOATING
C3455 VOUT.n257 VSS 0.4725f ; **FLOATING
C3456 VOUT.n258 VSS 0.21803f ; **FLOATING
C3457 VOUT.t22 VSS 0.05048f ; **FLOATING
C3458 VOUT.t1 VSS 0.05048f ; **FLOATING
C3459 VOUT.n259 VSS 0.4725f ; **FLOATING
C3460 VOUT.n260 VSS 0.16094f ; **FLOATING
C3461 VOUT.t147 VSS 0.05048f ; **FLOATING
C3462 VOUT.t120 VSS 0.05048f ; **FLOATING
C3463 VOUT.n261 VSS 0.4725f ; **FLOATING
C3464 VOUT.n262 VSS 0.22284f ; **FLOATING
C3465 VOUT.t7 VSS 0.05048f ; **FLOATING
C3466 VOUT.t10 VSS 0.05048f ; **FLOATING
C3467 VOUT.n263 VSS 0.4725f ; **FLOATING
C3468 VOUT.n264 VSS 0.21022f ; **FLOATING
C3469 VOUT.t29 VSS 0.05048f ; **FLOATING
C3470 VOUT.t2 VSS 0.05048f ; **FLOATING
C3471 VOUT.n265 VSS 0.4725f ; **FLOATING
C3472 VOUT.n266 VSS 0.16875f ; **FLOATING
C3473 VOUT.t18 VSS 0.05048f ; **FLOATING
C3474 VOUT.t25 VSS 0.05048f ; **FLOATING
C3475 VOUT.n267 VSS 0.4725f ; **FLOATING
C3476 VOUT.n268 VSS 0.22284f ; **FLOATING
C3477 VOUT.t19 VSS 0.05048f ; **FLOATING
C3478 VOUT.t125 VSS 0.05048f ; **FLOATING
C3479 VOUT.n269 VSS 0.4725f ; **FLOATING
C3480 VOUT.n270 VSS 0.20241f ; **FLOATING
C3481 VOUT.t164 VSS 0.05048f ; **FLOATING
C3482 VOUT.t9 VSS 0.05048f ; **FLOATING
C3483 VOUT.n271 VSS 0.4725f ; **FLOATING
C3484 VOUT.n272 VSS 0.17656f ; **FLOATING
C3485 VOUT.t27 VSS 0.05048f ; **FLOATING
C3486 VOUT.t162 VSS 0.05048f ; **FLOATING
C3487 VOUT.n273 VSS 0.4725f ; **FLOATING
C3488 VOUT.n274 VSS 0.22284f ; **FLOATING
C3489 VOUT.t21 VSS 0.05048f ; **FLOATING
C3490 VOUT.t134 VSS 0.05048f ; **FLOATING
C3491 VOUT.n275 VSS 0.4725f ; **FLOATING
C3492 VOUT.n276 VSS 0.19459f ; **FLOATING
C3493 VOUT.t131 VSS 0.05048f ; **FLOATING
C3494 VOUT.t163 VSS 0.05048f ; **FLOATING
C3495 VOUT.n277 VSS 0.47786f ; **FLOATING
C3496 VOUT.n278 VSS 0.45839f ; **FLOATING
C3497 VOUT.n279 VSS 5.73748f ; **FLOATING
C3498 VOUT.t136 VSS 3.44028f ; **FLOATING
C3499 VOUT.n280 VSS 7.13567f ; **FLOATING
C3500 VOUT.t132 VSS 22.4892f ; **FLOATING
C3501 VOUT.n281 VSS 5.70393f ; **FLOATING
C3502 EAOUT_BUF.t1 VSS 0.77597f ; **FLOATING
C3503 EAOUT_BUF.n0 VSS 1.77267f ; **FLOATING
C3504 EAOUT_BUF.t2 VSS 0.96858f ; **FLOATING
C3505 EAOUT_BUF.n1 VSS 2.40306f ; **FLOATING
C3506 EAOUT_BUF.t0 VSS 1.9704f ; **FLOATING
C3507 FB_BUF.t0 VSS 0.57105f ; **FLOATING
C3508 FB_BUF.n0 VSS 1.0444f ; **FLOATING
C3509 FB_BUF.t2 VSS 0.603f ; **FLOATING
C3510 FB_BUF.n1 VSS 1.46492f ; **FLOATING
C3511 FB_BUF.t1 VSS 1.27875f ; **FLOATING
C3512 VREF.t3 VSS 2.18975f ; **FLOATING
C3513 VREF.t2 VSS 2.11198f ; **FLOATING
C3514 VREF.n0 VSS 2.29688f ; **FLOATING
C3515 VREF.n1 VSS 4.43208f ; **FLOATING
C3516 VREF.t1 VSS 2.13181f ; **FLOATING
C3517 VREF.t0 VSS 2.11198f ; **FLOATING
C3518 VREF.n2 VSS 2.23637f ; **FLOATING
C3519 EN.t0 VSS 0.77199f ; **FLOATING
.ends
