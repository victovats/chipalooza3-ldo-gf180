* NGSPICE file created from v2_nbias.ext - technology: gf180mcuD

.subckt v2_nbias
X0 a_n865_n79# a_n985_n127# a_n1097_n79# a_n2536_n383# nfet_05v0 ad=0.35p pd=1.81u as=0.35p ps=1.81u w=1.25u l=0.6u
X1 a_n633_n79# a_n753_n127# a_n865_n79# a_n2536_n383# nfet_05v0 ad=0.35p pd=1.81u as=0.35p ps=1.81u w=1.25u l=0.6u
X2 a_n401_n79# a_n521_n127# a_n633_n79# a_n2536_n383# nfet_05v0 ad=0.35p pd=1.81u as=0.35p ps=1.81u w=1.25u l=0.6u
X3 a_n1561_n79# a_n1681_n127# a_n1801_n79# a_n2536_n383# nfet_05v0 ad=0.35p pd=1.81u as=0.75p ps=3.7u w=1.25u l=0.6u
X4 a_1681_n54# a_1561_n102# a_1441_n54# a_n2536_n383# nfet_05v0 ad=0.6p pd=3.2u as=0.6p ps=3.2u w=1u l=0.6u
X5 a_355_n79# a_355_n79# a_355_n79# a_n2536_n383# nfet_05v0 ad=0.725p pd=3.66u as=1.45p ps=7.32u w=1.25u l=0.6u
X6 a_n1329_n79# a_n1449_n127# a_n1561_n79# a_n2536_n383# nfet_05v0 ad=0.35p pd=1.81u as=0.35p ps=1.81u w=1.25u l=0.6u
X7 a_n1097_n79# a_n1217_n127# a_n1329_n79# a_n2536_n383# nfet_05v0 ad=0.35p pd=1.81u as=0.35p ps=1.81u w=1.25u l=0.6u
X8 a_1973_n54# a_1973_n54# a_1973_n54# a_n2536_n383# nfet_05v0 ad=0.58p pd=3.16u as=1.16p ps=6.32u w=1u l=0.6u
X9 a_n2325_n79# a_n2325_n79# a_n2325_n79# a_n2536_n383# nfet_05v0 ad=0.725p pd=3.66u as=1.45p ps=7.32u w=1.25u l=0.6u
X10 a_63_n79# a_n57_n127# a_n169_n79# a_n2536_n383# nfet_05v0 ad=0.75p pd=3.7u as=0.35p ps=1.81u w=1.25u l=0.6u
X11 a_917_n54# a_917_n54# a_917_n54# a_n2536_n383# nfet_05v0 ad=0.58p pd=3.16u as=1.16p ps=6.32u w=1u l=0.6u
X12 a_n169_n79# a_n289_n127# a_n401_n79# a_n2536_n383# nfet_05v0 ad=0.35p pd=1.81u as=0.35p ps=1.81u w=1.25u l=0.6u
.ends
